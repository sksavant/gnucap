// Generated by AMV-Generator, V2.0,2003
// Institute of Microelectronic Systems
// University of Hanover
//
// Generated on 09/29/03 at 18:14:23 */

`include "discipline.h"

module ota_simpl(  p_in , n_in , out1 , vdd , gnd);

// Ein- und Ausgangsknoten deklarieren:
inout  p_in , n_in , out1 , vdd , gnd;
electrical  p_in , n_in , out1 , vdd , gnd;

// Lokale Parameter deklarieren:

// Schalter deklarieren:
parameter real v_t = 0.025 ;

// Values deklarieren:
real gm;
real u_diff;

analog begin

u_diff = V(p_in) - V(n_in);
gm = 0.01 / (2 * v_t);

I(vdd,out1) <+ u_diff * gm;

  end
endmodule
