// R-TEST - test for verilog-a code generation

`define P(txt) (*txt*)
`include "discipline.h"

module rtest (top,low);

   inout top,low;
   electrical top,low;

   // Model parameters
   parameter real R1=10000 from (0:inf)
                  `P(info="Resistor [Ohm]");

   // Declaration of variables
   real v1, i1, g;

   analog begin
		@(initial_model) begin
			g=1/R1;
		end

      begin     //Bias-dependent model evaluation

		   v1 = V(top,low);
         i1 = v1*g;

      end       //Bias-dependent model evaluation

      begin     //Define branch sources

         I(top,low) <+ i1;

      end
   end

endmodule
