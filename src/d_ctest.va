// R-TEST - test for verilog-a code generation

`include "discipline.h"

module ctest (top,low);

   inout top,low;
   electrical top,low;

   // Model parameters
   parameter real c=1e-6 from [0:inf);

   // Declaration of variables
   real v1, i1;

   analog begin
      begin

		   v1 = V(top,low) ;
         I(top,low) <+ c*ddt(v1);

      end
   end

endmodule
