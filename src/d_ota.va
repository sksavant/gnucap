// Generated by AMV-Generator, V2.0,2003
// Institute of Microelectronic Systems
// University of Hanover
//
// Generated on 11/19/03 at 23:10:58 */

module ota(  p_in , n_in , out1 , pbias , nbias , vdd , gnd);

// Ein- und Ausgangsknoten deklarieren:
inout  p_in , n_in , out1 , pbias , nbias , vdd , gnd;
electrical  p_in , n_in , out1 , pbias , nbias , vdd , gnd;

 // Lokale Parameter deklarieren:
 parameter real ota_mbsim3v3_pmbtrans9_w = 0.100e-3 ;
 parameter real ota_mbsim3v3_pmbtrans9_l = 0.100e-4 ;
 parameter real ota_mbsim3v3_pmbtrans20_w = 0.100e-3 ;
 parameter real ota_mbsim3v3_pmbtrans20_l = 0.100e-4 ;
 parameter real ota_mbsim3v3_p_mos_vth0 = -0.53 ;
 parameter real ota_mbsim3v3_n_mos_vth0 = 0.54 ;
 parameter real ota_mbsim3v3_pmtrans1_w = 0.20e-4 ;
 parameter real ota_mbsim3v3_pmtrans1_l = 0.10e-4 ;
 parameter real ota_mbsim3v3_pmtrans2_w = 0.20e-4 ;
 parameter real ota_mbsim3v3_pmtrans2_l = 0.10e-4 ;
 parameter real ota_mbsim3v3_nmtrans1_w = 0.10e-4 ;
 parameter real ota_mbsim3v3_nmtrans1_l = 0.10e-4 ;
 parameter real ota_mbsim3v3_nmtrans2_w = 0.10e-4 ;
 parameter real ota_mbsim3v3_nmtrans2_l = 0.10e-4 ;
 parameter real ota_mbsim3v3_nmtrans3_w = 0.10e-4 ;
 parameter real ota_mbsim3v3_nmtrans3_l = 0.10e-4 ;

 // Schalter deklarieren:
 parameter real _a1 = 1.0 ;
 parameter real _a2 = 1.0 ;
 parameter real _a3 = 1.0 ;
 parameter real _a4 = 1.0 ;
 parameter real _a5 = 1.0 ;
 parameter real _a6 = 1.0 ;
 parameter real _a7 = 1.0 ;
 parameter real _a8 = 1.0 ;
 parameter real _a9 = 1.0 ;
 parameter real _a10 = 1.0 ;
 parameter real _a11 = 1.0 ;
 parameter real _a12 = 1.0 ;
 parameter real _a13 = 1.0 ;
 parameter real _a14 = 1.0 ;
 parameter real _a15 = 1.0 ;
 parameter real _a16 = 1.0 ;
 parameter real _a17 = 1.0 ;
 parameter real _a18 = 1.0 ;
 parameter real _a19 = 1.0 ;
 parameter real _a20 = 1.0 ;
 parameter real _a21 = 1.0 ;
 parameter real _a22 = 1.0 ;
 parameter real _a23 = 1.0 ;
 parameter real _a24 = 1.0 ;
 parameter real _a25 = 1.0 ;
 parameter real _a26 = 1.0 ;
 parameter real _a27 = 1.0 ;
 parameter real _a28 = 1.0 ;
 parameter real _a29 = 1.0 ;
 parameter real _a30 = 1.0 ;
 parameter real _a31 = 1.0 ;
 parameter real _a32 = 1.0 ;
 parameter real _a33 = 1.0 ;
 parameter real _a34 = 1.0 ;
 parameter real _a35 = 1.0 ;
 parameter real _a36 = 1.0 ;
 parameter real _a37 = 1.0 ;
 parameter real _a38 = 1.0 ;
 parameter real _a39 = 1.0 ;
 parameter real _a40 = 1.0 ;
 parameter real _a41 = 1.0 ;
 parameter real _a42 = 1.0 ;
 parameter real _a43 = 1.0 ;
 parameter real _a44 = 1.0 ;
 parameter real _a45 = 1.0 ;
 parameter real _a46 = 1.0 ;
 parameter real _a47 = 1.0 ;
 parameter real _a48 = 1.0 ;
 parameter real _a49 = 1.0 ;
 parameter real _a50 = 1.0 ;
 parameter real _a51 = 1.0 ;
 parameter real _a52 = 1.0 ;
 parameter real _a53 = 1.0 ;
 parameter real _a54 = 1.0 ;
 parameter real _a55 = 1.0 ;
 parameter real _a56 = 1.0 ;
 parameter real _a57 = 1.0 ;
 parameter real _a58 = 1.0 ;
 parameter real _a59 = 1.0 ;
 parameter real _a60 = 1.0 ;
 parameter real _a61 = 1.0 ;
 parameter real _a62 = 1.0 ;
 parameter real _a63 = 1.0 ;
 parameter real _a64 = 1.0 ;
 parameter real _a65 = 1.0 ;
 parameter real _a66 = 1.0 ;
 parameter real _a67 = 1.0 ;
 parameter real _a68 = 1.0 ;
 parameter real _a69 = 1.0 ;
 parameter real _a70 = 1.0 ;
 parameter real _a71 = 1.0 ;
 parameter real _a72 = 1.0 ;
 parameter real _a73 = 1.0 ;
 parameter real _a74 = 1.0 ;
 parameter real _a75 = 1.0 ;
 parameter real _a76 = 1.0 ;
 parameter real _a77 = 1.0 ;
 parameter real _a78 = 1.0 ;
 parameter real _a79 = 1.0 ;
 parameter real _a80 = 1.0 ;
 parameter real _a81 = 1.0 ;
 parameter real _a82 = 1.0 ;
 parameter real _a83 = 1.0 ;
 parameter real _a84 = 1.0 ;
 parameter real _a85 = 1.0 ;
 parameter real _a86 = 1.0 ;
 parameter real _a87 = 1.0 ;
 parameter real _a88 = 1.0 ;
 parameter real _a89 = 1.0 ;
 parameter real _a90 = 1.0 ;
 parameter real _a91 = 1.0 ;
 parameter real _a92 = 1.0 ;
 parameter real _a93 = 1.0 ;
 parameter real _a94 = 1.0 ;
 parameter real _a95 = 1.0 ;
 parameter real _a96 = 1.0 ;
 parameter real _a97 = 1.0 ;
 parameter real _a98 = 1.0 ;
 parameter real _a99 = 1.0 ;
 parameter real _a100 = 1.0 ;
 parameter real _a101 = 1.0 ;
 parameter real _a102 = 1.0 ;
 parameter real _a103 = 1.0 ;
 parameter real _a104 = 1.0 ;
 parameter real _a105 = 1.0 ;
 parameter real _a106 = 1.0 ;
 parameter real _a107 = 1.0 ;
 parameter real _a108 = 1.0 ;
 parameter real _a109 = 1.0 ;
 parameter real _a110 = 1.0 ;
 parameter real _a111 = 1.0 ;
 parameter real _a112 = 1.0 ;
 parameter real _a113 = 1.0 ;
 parameter real _a114 = 1.0 ;
 parameter real _a115 = 1.0 ;
 parameter real _a116 = 1.0 ;
 parameter real _a117 = 1.0 ;
 parameter real _a118 = 1.0 ;
 parameter real _a119 = 1.0 ;
 parameter real _a120 = 1.0 ;
 parameter real _a121 = 1.0 ;
 parameter real _a122 = 1.0 ;
 parameter real _a123 = 1.0 ;
 parameter real _a124 = 1.0 ;
 parameter real _a125 = 1.0 ;
 parameter real _a126 = 1.0 ;
 parameter real _a127 = 1.0 ;
 parameter real _a128 = 1.0 ;
 parameter real _a129 = 1.0 ;
 parameter real _a130 = 1.0 ;
 parameter real _a131 = 1.0 ;
 parameter real _a132 = 1.0 ;
 parameter real _a133 = 1.0 ;
 parameter real _a134 = 1.0 ;
 parameter real _a135 = 1.0 ;
 parameter real _a136 = 1.0 ;
 parameter real _a137 = 1.0 ;
 parameter real _a138 = 1.0 ;
 parameter real _a139 = 1.0 ;
 parameter real _a140 = 1.0 ;
 parameter real _a141 = 1.0 ;
 parameter real _a142 = 1.0 ;
 parameter real _a143 = 1.0 ;
 parameter real _a144 = 1.0 ;
 parameter real _a145 = 1.0 ;
 parameter real _a146 = 1.0 ;
 parameter real _a147 = 1.0 ;
 parameter real _a148 = 1.0 ;
 parameter real _a149 = 1.0 ;
 parameter real _a150 = 1.0 ;
 parameter real _a151 = 1.0 ;
 parameter real _a152 = 1.0 ;
 parameter real _a153 = 1.0 ;
 parameter real _a154 = 1.0 ;
 parameter real _a155 = 1.0 ;
 parameter real _a156 = 1.0 ;
 parameter real _a157 = 1.0 ;
 parameter real _a158 = 1.0 ;
 parameter real _a159 = 1.0 ;
 parameter real _a160 = 1.0 ;
 parameter real _a161 = 1.0 ;
 parameter real _a162 = 1.0 ;
 parameter real _a163 = 1.0 ;
 parameter real _a164 = 1.0 ;
 parameter real _a165 = 1.0 ;
 parameter real _a166 = 1.0 ;
 parameter real _a167 = 1.0 ;
 parameter real _a168 = 1.0 ;

 // Vars ohne deklarieren:
 electrical u_int1 ;

 // Values deklarieren:
 electrical f_pmtrans1_g_t ;
 electrical f_pmtrans1_g_ni ;
 electrical f_pmtrans1_g_k2 ;
 electrical f_pmtrans1_g_k1 ;
 electrical f_pmtrans1_vgsi ;
 electrical f_pmtrans1_vdsi ;
 electrical f_pmtrans1_vbsi ;
 electrical f_pmtrans1_dir ;
 electrical f_pmtrans1_vgs ;
 electrical f_pmtrans1_vds ;
 electrical f_pmtrans1_vbs ;
 electrical f_pmtrans1_g_y ;
 electrical f_pmtrans1_vbc ;
 electrical f_pmtrans1_vbseff ;
 electrical f_pmtrans1_sqrtphis ;
 electrical f_pmtrans1_leff ;
 electrical f_pmtrans1_weff_strich ;
 electrical f_pmtrans1_leff_cv ;
 electrical f_pmtrans1_lt1 ;
 electrical f_pmtrans1_theta0vb0 ;
 electrical f_pmtrans1_v0 ;
 electrical f_pmtrans1_delt_vth ;
 electrical f_pmtrans1_vth_t22 ;
 electrical f_pmtrans1_vth_t1_t1 ;
 electrical f_pmtrans1_vth ;
 electrical f_pmtrans1_scvt ;
 electrical f_pmtrans1_nvgs ;
 electrical f_pmtrans1_vgsteff ;
 electrical f_pmtrans1_weff ;
 electrical f_pmtrans1_ueff ;
 electrical f_pmtrans1_abulkp ;
 electrical f_pmtrans1_abulk ;
 electrical f_pmtrans1_temp3 ;
 electrical f_pmtrans1_temp2 ;
 electrical f_pmtrans1_vdsat ;
 electrical f_pmtrans1_vdseff ;
 electrical f_pmtrans1_vasat_t9 ;
 electrical f_pmtrans1_vasat_t0 ;
 electrical f_pmtrans1_vasat ;
 electrical f_pmtrans1_e_vascbe ;
 electrical f_pmtrans1_vadiblc ;
 electrical f_pmtrans1_vaclm ;
 electrical f_pmtrans1_vafaktor ;
 electrical f_pmtrans1_va ;
 electrical f_pmtrans1_idso ;
 electrical f_pmtrans1_idsx ;
 electrical f_pmtrans1_ids ;
 electrical f_pmtrans1_cgdo_strich ;
 electrical f_pmtrans1_cgso_strich ;
 electrical f_pmtrans1_echte_vgd ;
 electrical f_pmtrans1_echte_vgs ;
 electrical f_pmtrans1_echte_vgb ;
 electrical f_pmtrans1_qgdo_T0 ;
 electrical f_pmtrans1_qgdo_T1 ;
 electrical f_pmtrans1_qgdo_T2 ;
 electrical f_pmtrans1_qgdo_T3 ;
 electrical f_pmtrans1_qgdo_T4 ;
 electrical f_pmtrans1_qgso_T0 ;
 electrical f_pmtrans1_qgso_T1 ;
 electrical f_pmtrans1_qgso_T2 ;
 electrical f_pmtrans1_qgso_T3 ;
 electrical f_pmtrans1_qgso_T4 ;
 electrical f_pmtrans1_qoverlap_d ;
 electrical f_pmtrans1_qoverlap_s ;
 electrical f_pmtrans1_v3 ;
 electrical f_pmtrans1_vfbeff ;
 electrical f_pmtrans1_qac0 ;
 electrical f_pmtrans1_abulk_cv ;
 electrical f_pmtrans1_vdsat_cv ;
 electrical f_pmtrans1_qsub0 ;
 electrical f_pmtrans1_vdseff_cv ;
 electrical f_pmtrans1_faktor_t1 ;
 electrical f_pmtrans1_qs_ohne_o ;
 electrical f_pmtrans1_g_qg ;
 electrical f_pmtrans1_qg ;
 electrical f_pmtrans1_g_qb ;
 electrical f_pmtrans1_qb ;
 electrical f_pmtrans1_g_qd ;
 electrical f_pmtrans1_qd ;
 electrical f_pmtrans1_qs ;
 electrical f_pmtrans2_g_t ;
 electrical f_pmtrans2_g_ni ;
 electrical f_pmtrans2_g_k2 ;
 electrical f_pmtrans2_g_k1 ;
 electrical f_pmtrans2_vgsi ;
 electrical f_pmtrans2_vdsi ;
 electrical f_pmtrans2_vbsi ;
 electrical f_pmtrans2_dir ;
 electrical f_pmtrans2_vgs ;
 electrical f_pmtrans2_vds ;
 electrical f_pmtrans2_vbs ;
 electrical f_pmtrans2_g_y ;
 electrical f_pmtrans2_vbc ;
 electrical f_pmtrans2_vbseff ;
 electrical f_pmtrans2_sqrtphis ;
 electrical f_pmtrans2_leff ;
 electrical f_pmtrans2_weff_strich ;
 electrical f_pmtrans2_leff_cv ;
 electrical f_pmtrans2_lt1 ;
 electrical f_pmtrans2_theta0vb0 ;
 electrical f_pmtrans2_v0 ;
 electrical f_pmtrans2_delt_vth ;
 electrical f_pmtrans2_vth_t22 ;
 electrical f_pmtrans2_vth_t1_t1 ;
 electrical f_pmtrans2_vth ;
 electrical f_pmtrans2_scvt ;
 electrical f_pmtrans2_nvgs ;
 electrical f_pmtrans2_vgsteff ;
 electrical f_pmtrans2_weff ;
 electrical f_pmtrans2_ueff ;
 electrical f_pmtrans2_abulkp ;
 electrical f_pmtrans2_abulk ;
 electrical f_pmtrans2_temp3 ;
 electrical f_pmtrans2_temp2 ;
 electrical f_pmtrans2_vdsat ;
 electrical f_pmtrans2_vdseff ;
 electrical f_pmtrans2_vasat_t9 ;
 electrical f_pmtrans2_vasat_t0 ;
 electrical f_pmtrans2_vasat ;
 electrical f_pmtrans2_e_vascbe ;
 electrical f_pmtrans2_vadiblc ;
 electrical f_pmtrans2_vaclm ;
 electrical f_pmtrans2_vafaktor ;
 electrical f_pmtrans2_va ;
 electrical f_pmtrans2_idso ;
 electrical f_pmtrans2_idsx ;
 electrical f_pmtrans2_ids ;
 electrical f_pmtrans2_cgdo_strich ;
 electrical f_pmtrans2_cgso_strich ;
 electrical f_pmtrans2_echte_vgd ;
 electrical f_pmtrans2_echte_vgs ;
 electrical f_pmtrans2_echte_vgb ;
 electrical f_pmtrans2_qgdo_T0 ;
 electrical f_pmtrans2_qgdo_T1 ;
 electrical f_pmtrans2_qgdo_T2 ;
 electrical f_pmtrans2_qgdo_T3 ;
 electrical f_pmtrans2_qgdo_T4 ;
 electrical f_pmtrans2_qgso_T0 ;
 electrical f_pmtrans2_qgso_T1 ;
 electrical f_pmtrans2_qgso_T2 ;
 electrical f_pmtrans2_qgso_T3 ;
 electrical f_pmtrans2_qgso_T4 ;
 electrical f_pmtrans2_qoverlap_d ;
 electrical f_pmtrans2_qoverlap_s ;
 electrical f_pmtrans2_v3 ;
 electrical f_pmtrans2_vfbeff ;
 electrical f_pmtrans2_qac0 ;
 electrical f_pmtrans2_abulk_cv ;
 electrical f_pmtrans2_vdsat_cv ;
 electrical f_pmtrans2_qsub0 ;
 electrical f_pmtrans2_vdseff_cv ;
 electrical f_pmtrans2_faktor_t1 ;
 electrical f_pmtrans2_qs_ohne_o ;
 electrical f_pmtrans2_g_qg ;
 electrical f_pmtrans2_qg ;
 electrical f_pmtrans2_g_qb ;
 electrical f_pmtrans2_qb ;
 electrical f_pmtrans2_g_qd ;
 electrical f_pmtrans2_qd ;
 electrical f_pmtrans2_qs ;
 electrical f_nmtrans1_g_t ;
 electrical f_nmtrans1_g_ni ;
 electrical f_nmtrans1_g_k2 ;
 electrical f_nmtrans1_g_k1 ;
 electrical f_nmtrans1_vgsi ;
 electrical f_nmtrans1_vdsi ;
 electrical f_nmtrans1_vbsi ;
 electrical f_nmtrans1_dir ;
 electrical f_nmtrans1_vgs ;
 electrical f_nmtrans1_vds ;
 electrical f_nmtrans1_vbs ;
 electrical f_nmtrans1_g_y ;
 electrical f_nmtrans1_vbc ;
 electrical f_nmtrans1_vbseff ;
 electrical f_nmtrans1_sqrtphis ;
 electrical f_nmtrans1_leff ;
 electrical f_nmtrans1_weff_strich ;
 electrical f_nmtrans1_leff_cv ;
 electrical f_nmtrans1_lt1 ;
 electrical f_nmtrans1_theta0vb0 ;
 electrical f_nmtrans1_v0 ;
 electrical f_nmtrans1_delt_vth ;
 electrical f_nmtrans1_vth_t22 ;
 electrical f_nmtrans1_vth_t1_t1 ;
 electrical f_nmtrans1_vth ;
 electrical f_nmtrans1_scvt ;
 electrical f_nmtrans1_nvgs ;
 electrical f_nmtrans1_vgsteff ;
 electrical f_nmtrans1_weff ;
 electrical f_nmtrans1_ueff ;
 electrical f_nmtrans1_abulkp ;
 electrical f_nmtrans1_abulk ;
 electrical f_nmtrans1_temp3 ;
 electrical f_nmtrans1_temp2 ;
 electrical f_nmtrans1_vdsat ;
 electrical f_nmtrans1_vdseff ;
 electrical f_nmtrans1_vasat_t9 ;
 electrical f_nmtrans1_vasat_t0 ;
 electrical f_nmtrans1_vasat ;
 electrical f_nmtrans1_e_vascbe ;
 electrical f_nmtrans1_vadiblc ;
 electrical f_nmtrans1_vaclm ;
 electrical f_nmtrans1_vafaktor ;
 electrical f_nmtrans1_va ;
 electrical f_nmtrans1_idso ;
 electrical f_nmtrans1_idsx ;
 electrical f_nmtrans1_ids ;
 electrical f_nmtrans1_cgdo_strich ;
 electrical f_nmtrans1_cgso_strich ;
 electrical f_nmtrans1_echte_vgd ;
 electrical f_nmtrans1_echte_vgs ;
 electrical f_nmtrans1_echte_vgb ;
 electrical f_nmtrans1_qgdo_T0 ;
 electrical f_nmtrans1_qgdo_T1 ;
 electrical f_nmtrans1_qgdo_T2 ;
 electrical f_nmtrans1_qgdo_T3 ;
 electrical f_nmtrans1_qgdo_T4 ;
 electrical f_nmtrans1_qgso_T0 ;
 electrical f_nmtrans1_qgso_T1 ;
 electrical f_nmtrans1_qgso_T2 ;
 electrical f_nmtrans1_qgso_T3 ;
 electrical f_nmtrans1_qgso_T4 ;
 electrical f_nmtrans1_qoverlap_d ;
 electrical f_nmtrans1_qoverlap_s ;
 electrical f_nmtrans1_v3 ;
 electrical f_nmtrans1_vfbeff ;
 electrical f_nmtrans1_qac0 ;
 electrical f_nmtrans1_abulk_cv ;
 electrical f_nmtrans1_vdsat_cv ;
 electrical f_nmtrans1_qsub0 ;
 electrical f_nmtrans1_vdseff_cv ;
 electrical f_nmtrans1_faktor_t1 ;
 electrical f_nmtrans1_qs_ohne_o ;
 electrical f_nmtrans1_g_qg ;
 electrical f_nmtrans1_qg ;
 electrical f_nmtrans1_g_qb ;
 electrical f_nmtrans1_qb ;
 electrical f_nmtrans1_g_qd ;
 electrical f_nmtrans1_qd ;
 electrical f_nmtrans1_qs ;
 electrical f_nmtrans2_g_t ;
 electrical f_nmtrans2_g_ni ;
 electrical f_nmtrans2_g_k2 ;
 electrical f_nmtrans2_g_k1 ;
 electrical f_nmtrans2_vgsi ;
 electrical f_nmtrans2_vdsi ;
 electrical f_nmtrans2_vbsi ;
 electrical f_nmtrans2_dir ;
 electrical f_nmtrans2_vgs ;
 electrical f_nmtrans2_vds ;
 electrical f_nmtrans2_vbs ;
 electrical f_nmtrans2_g_y ;
 electrical f_nmtrans2_vbc ;
 electrical f_nmtrans2_vbseff ;
 electrical f_nmtrans2_sqrtphis ;
 electrical f_nmtrans2_leff ;
 electrical f_nmtrans2_weff_strich ;
 electrical f_nmtrans2_leff_cv ;
 electrical f_nmtrans2_lt1 ;
 electrical f_nmtrans2_theta0vb0 ;
 electrical f_nmtrans2_v0 ;
 electrical f_nmtrans2_delt_vth ;
 electrical f_nmtrans2_vth_t22 ;
 electrical f_nmtrans2_vth_t1_t1 ;
 electrical f_nmtrans2_vth ;
 electrical f_nmtrans2_scvt ;
 electrical f_nmtrans2_nvgs ;
 electrical f_nmtrans2_vgsteff ;
 electrical f_nmtrans2_weff ;
 electrical f_nmtrans2_ueff ;
 electrical f_nmtrans2_abulkp ;
 electrical f_nmtrans2_abulk ;
 electrical f_nmtrans2_temp3 ;
 electrical f_nmtrans2_temp2 ;
 electrical f_nmtrans2_vdsat ;
 electrical f_nmtrans2_vdseff ;
 electrical f_nmtrans2_vasat_t9 ;
 electrical f_nmtrans2_vasat_t0 ;
 electrical f_nmtrans2_vasat ;
 electrical f_nmtrans2_e_vascbe ;
 electrical f_nmtrans2_vadiblc ;
 electrical f_nmtrans2_vaclm ;
 electrical f_nmtrans2_vafaktor ;
 electrical f_nmtrans2_va ;
 electrical f_nmtrans2_idso ;
 electrical f_nmtrans2_idsx ;
 electrical f_nmtrans2_ids ;
 electrical f_nmtrans2_cgdo_strich ;
 electrical f_nmtrans2_cgso_strich ;
 electrical f_nmtrans2_echte_vgd ;
 electrical f_nmtrans2_echte_vgs ;
 electrical f_nmtrans2_echte_vgb ;
 electrical f_nmtrans2_qgdo_T0 ;
 electrical f_nmtrans2_qgdo_T1 ;
 electrical f_nmtrans2_qgdo_T2 ;
 electrical f_nmtrans2_qgdo_T3 ;
 electrical f_nmtrans2_qgdo_T4 ;
 electrical f_nmtrans2_qgso_T0 ;
 electrical f_nmtrans2_qgso_T1 ;
 electrical f_nmtrans2_qgso_T2 ;
 electrical f_nmtrans2_qgso_T3 ;
 electrical f_nmtrans2_qgso_T4 ;
 electrical f_nmtrans2_qoverlap_d ;
 electrical f_nmtrans2_qoverlap_s ;
 electrical f_nmtrans2_v3 ;
 electrical f_nmtrans2_vfbeff ;
 electrical f_nmtrans2_qac0 ;
 electrical f_nmtrans2_abulk_cv ;
 electrical f_nmtrans2_vdsat_cv ;
 electrical f_nmtrans2_qsub0 ;
 electrical f_nmtrans2_vdseff_cv ;
 electrical f_nmtrans2_faktor_t1 ;
 electrical f_nmtrans2_qs_ohne_o ;
 electrical f_nmtrans2_g_qg ;
 electrical f_nmtrans2_qg ;
 electrical f_nmtrans2_g_qb ;
 electrical f_nmtrans2_qb ;
 electrical f_nmtrans2_g_qd ;
 electrical f_nmtrans2_qd ;
 electrical f_nmtrans2_qs ;
 electrical f_nmtrans3_g_t ;
 electrical f_nmtrans3_g_ni ;
 electrical f_nmtrans3_g_k2 ;
 electrical f_nmtrans3_g_k1 ;
 electrical f_nmtrans3_vgsi ;
 electrical f_nmtrans3_vdsi ;
 electrical f_nmtrans3_vbsi ;
 electrical f_nmtrans3_dir ;
 electrical f_nmtrans3_vgs ;
 electrical f_nmtrans3_vds ;
 electrical f_nmtrans3_vbs ;
 electrical f_nmtrans3_g_y ;
 electrical f_nmtrans3_vbc ;
 electrical f_nmtrans3_vbseff ;
 electrical f_nmtrans3_sqrtphis ;
 electrical f_nmtrans3_leff ;
 electrical f_nmtrans3_weff_strich ;
 electrical f_nmtrans3_leff_cv ;
 electrical f_nmtrans3_lt1 ;
 electrical f_nmtrans3_theta0vb0 ;
 electrical f_nmtrans3_v0 ;
 electrical f_nmtrans3_delt_vth ;
 electrical f_nmtrans3_vth_t22 ;
 electrical f_nmtrans3_vth_t1_t1 ;
 electrical f_nmtrans3_vth ;
 electrical f_nmtrans3_scvt ;
 electrical f_nmtrans3_nvgs ;
 electrical f_nmtrans3_vgsteff ;
 electrical f_nmtrans3_weff ;
 electrical f_nmtrans3_ueff ;
 electrical f_nmtrans3_abulkp ;
 electrical f_nmtrans3_abulk ;
 electrical f_nmtrans3_temp3 ;
 electrical f_nmtrans3_temp2 ;
 electrical f_nmtrans3_vdsat ;
 electrical f_nmtrans3_vdseff ;
 electrical f_nmtrans3_vasat_t9 ;
 electrical f_nmtrans3_vasat_t0 ;
 electrical f_nmtrans3_vasat ;
 electrical f_nmtrans3_e_vascbe ;
 electrical f_nmtrans3_vadiblc ;
 electrical f_nmtrans3_vaclm ;
 electrical f_nmtrans3_vafaktor ;
 electrical f_nmtrans3_va ;
 electrical f_nmtrans3_idso ;
 electrical f_nmtrans3_idsx ;
 electrical f_nmtrans3_ids ;
 electrical f_nmtrans3_cgdo_strich ;
 electrical f_nmtrans3_cgso_strich ;
 electrical f_nmtrans3_echte_vgd ;
 electrical f_nmtrans3_echte_vgs ;
 electrical f_nmtrans3_echte_vgb ;
 electrical f_nmtrans3_qgdo_T0 ;
 electrical f_nmtrans3_qgdo_T1 ;
 electrical f_nmtrans3_qgdo_T2 ;
 electrical f_nmtrans3_qgdo_T3 ;
 electrical f_nmtrans3_qgdo_T4 ;
 electrical f_nmtrans3_qgso_T0 ;
 electrical f_nmtrans3_qgso_T1 ;
 electrical f_nmtrans3_qgso_T2 ;
 electrical f_nmtrans3_qgso_T3 ;
 electrical f_nmtrans3_qgso_T4 ;
 electrical f_nmtrans3_qoverlap_d ;
 electrical f_nmtrans3_qoverlap_s ;
 electrical f_nmtrans3_v3 ;
 electrical f_nmtrans3_vfbeff ;
 electrical f_nmtrans3_qac0 ;
 electrical f_nmtrans3_abulk_cv ;
 electrical f_nmtrans3_vdsat_cv ;
 electrical f_nmtrans3_qsub0 ;
 electrical f_nmtrans3_vdseff_cv ;
 electrical f_nmtrans3_faktor_t1 ;
 electrical f_nmtrans3_qs_ohne_o ;
 electrical f_nmtrans3_g_qg ;
 electrical f_nmtrans3_qg ;
 electrical f_nmtrans3_g_qb ;
 electrical f_nmtrans3_qb ;
 electrical f_nmtrans3_g_qd ;
 electrical f_nmtrans3_qd ;
 electrical f_nmtrans3_qs ;
 electrical f_pmbtrans9_g_t ;
 electrical f_pmbtrans9_g_ni ;
 electrical f_pmbtrans9_g_k2 ;
 electrical f_pmbtrans9_g_k1 ;
 electrical f_pmbtrans9_vgsi ;
 electrical f_pmbtrans9_vdsi ;
 electrical f_pmbtrans9_vbsi ;
 electrical f_pmbtrans9_dir ;
 electrical f_pmbtrans9_vgs ;
 electrical f_pmbtrans9_vds ;
 electrical f_pmbtrans9_vbs ;
 electrical f_pmbtrans9_g_y ;
 electrical f_pmbtrans9_vbc ;
 electrical f_pmbtrans9_vbseff ;
 electrical f_pmbtrans9_sqrtphis ;
 electrical f_pmbtrans9_leff ;
 electrical f_pmbtrans9_weff_strich ;
 electrical f_pmbtrans9_leff_cv ;
 electrical f_pmbtrans9_lt1 ;
 electrical f_pmbtrans9_theta0vb0 ;
 electrical f_pmbtrans9_v0 ;
 electrical f_pmbtrans9_delt_vth ;
 electrical f_pmbtrans9_vth_t22 ;
 electrical f_pmbtrans9_vth_t1_t1 ;
 electrical f_pmbtrans9_vth ;
 electrical f_pmbtrans9_scvt ;
 electrical f_pmbtrans9_nvgs ;
 electrical f_pmbtrans9_vgsteff ;
 electrical f_pmbtrans9_weff ;
 electrical f_pmbtrans9_ueff ;
 electrical f_pmbtrans9_abulkp ;
 electrical f_pmbtrans9_abulk ;
 electrical f_pmbtrans9_temp3 ;
 electrical f_pmbtrans9_temp2 ;
 electrical f_pmbtrans9_vdsat ;
 electrical f_pmbtrans9_vdseff ;
 electrical f_pmbtrans9_vasat_t9 ;
 electrical f_pmbtrans9_vasat_t0 ;
 electrical f_pmbtrans9_vasat ;
 electrical f_pmbtrans9_e_vascbe ;
 electrical f_pmbtrans9_vadiblc ;
 electrical f_pmbtrans9_vaclm ;
 electrical f_pmbtrans9_vafaktor ;
 electrical f_pmbtrans9_va ;
 electrical f_pmbtrans9_idso ;
 electrical f_pmbtrans9_idsx ;
 electrical f_pmbtrans9_ids ;
 electrical f_pmbtrans9_cgdo_strich ;
 electrical f_pmbtrans9_cgso_strich ;
 electrical f_pmbtrans9_echte_vgd ;
 electrical f_pmbtrans9_echte_vgs ;
 electrical f_pmbtrans9_echte_vgb ;
 electrical f_pmbtrans9_qgdo_T0 ;
 electrical f_pmbtrans9_qgdo_T1 ;
 electrical f_pmbtrans9_qgdo_T2 ;
 electrical f_pmbtrans9_qgdo_T3 ;
 electrical f_pmbtrans9_qgdo_T4 ;
 electrical f_pmbtrans9_qgso_T0 ;
 electrical f_pmbtrans9_qgso_T1 ;
 electrical f_pmbtrans9_qgso_T2 ;
 electrical f_pmbtrans9_qgso_T3 ;
 electrical f_pmbtrans9_qgso_T4 ;
 electrical f_pmbtrans9_qoverlap_d ;
 electrical f_pmbtrans9_qoverlap_s ;
 electrical f_pmbtrans9_v3 ;
 electrical f_pmbtrans9_vfbeff ;
 electrical f_pmbtrans9_qac0 ;
 electrical f_pmbtrans9_abulk_cv ;
 electrical f_pmbtrans9_vdsat_cv ;
 electrical f_pmbtrans9_qsub0 ;
 electrical f_pmbtrans9_vdseff_cv ;
 electrical f_pmbtrans9_faktor_t1 ;
 electrical f_pmbtrans9_qs_ohne_o ;
 electrical f_pmbtrans9_g_qg ;
 electrical f_pmbtrans9_qg ;
 electrical f_pmbtrans9_g_qb ;
 electrical f_pmbtrans9_qb ;
 electrical f_pmbtrans9_g_qd ;
 electrical f_pmbtrans9_qd ;
 electrical f_pmbtrans9_qs ;
 electrical f_pmbtrans20_g_t ;
 electrical f_pmbtrans20_g_ni ;
 electrical f_pmbtrans20_g_k2 ;
 electrical f_pmbtrans20_g_k1 ;
 electrical f_pmbtrans20_vgsi ;
 electrical f_pmbtrans20_vdsi ;
 electrical f_pmbtrans20_vbsi ;
 electrical f_pmbtrans20_dir ;
 electrical f_pmbtrans20_vgs ;
 electrical f_pmbtrans20_vds ;
 electrical f_pmbtrans20_vbs ;
 electrical f_pmbtrans20_g_y ;
 electrical f_pmbtrans20_vbc ;
 electrical f_pmbtrans20_vbseff ;
 electrical f_pmbtrans20_sqrtphis ;
 electrical f_pmbtrans20_leff ;
 electrical f_pmbtrans20_weff_strich ;
 electrical f_pmbtrans20_leff_cv ;
 electrical f_pmbtrans20_lt1 ;
 electrical f_pmbtrans20_theta0vb0 ;
 electrical f_pmbtrans20_v0 ;
 electrical f_pmbtrans20_delt_vth ;
 electrical f_pmbtrans20_vth_t22 ;
 electrical f_pmbtrans20_vth_t1_t1 ;
 electrical f_pmbtrans20_vth ;
 electrical f_pmbtrans20_scvt ;
 electrical f_pmbtrans20_nvgs ;
 electrical f_pmbtrans20_vgsteff ;
 electrical f_pmbtrans20_weff ;
 electrical f_pmbtrans20_ueff ;
 electrical f_pmbtrans20_abulkp ;
 electrical f_pmbtrans20_abulk ;
 electrical f_pmbtrans20_temp3 ;
 electrical f_pmbtrans20_temp2 ;
 electrical f_pmbtrans20_vdsat ;
 electrical f_pmbtrans20_vdseff ;
 electrical f_pmbtrans20_vasat_t9 ;
 electrical f_pmbtrans20_vasat_t0 ;
 electrical f_pmbtrans20_vasat ;
 electrical f_pmbtrans20_e_vascbe ;
 electrical f_pmbtrans20_vadiblc ;
 electrical f_pmbtrans20_vaclm ;
 electrical f_pmbtrans20_vafaktor ;
 electrical f_pmbtrans20_va ;
 electrical f_pmbtrans20_idso ;
 electrical f_pmbtrans20_idsx ;
 electrical f_pmbtrans20_ids ;
 electrical f_pmbtrans20_cgdo_strich ;
 electrical f_pmbtrans20_cgso_strich ;
 electrical f_pmbtrans20_echte_vgd ;
 electrical f_pmbtrans20_echte_vgs ;
 electrical f_pmbtrans20_echte_vgb ;
 electrical f_pmbtrans20_qgdo_T0 ;
 electrical f_pmbtrans20_qgdo_T1 ;
 electrical f_pmbtrans20_qgdo_T2 ;
 electrical f_pmbtrans20_qgdo_T3 ;
 electrical f_pmbtrans20_qgdo_T4 ;
 electrical f_pmbtrans20_qgso_T0 ;
 electrical f_pmbtrans20_qgso_T1 ;
 electrical f_pmbtrans20_qgso_T2 ;
 electrical f_pmbtrans20_qgso_T3 ;
 electrical f_pmbtrans20_qgso_T4 ;
 electrical f_pmbtrans20_qoverlap_d ;
 electrical f_pmbtrans20_qoverlap_s ;
 electrical f_pmbtrans20_v3 ;
 electrical f_pmbtrans20_vfbeff ;
 electrical f_pmbtrans20_qac0 ;
 electrical f_pmbtrans20_abulk_cv ;
 electrical f_pmbtrans20_vdsat_cv ;
 electrical f_pmbtrans20_qsub0 ;
 electrical f_pmbtrans20_vdseff_cv ;
 electrical f_pmbtrans20_faktor_t1 ;
 electrical f_pmbtrans20_qs_ohne_o ;
 electrical f_pmbtrans20_g_qg ;
 electrical f_pmbtrans20_qg ;
 electrical f_pmbtrans20_g_qb ;
 electrical f_pmbtrans20_qb ;
 electrical f_pmbtrans20_g_qd ;
 electrical f_pmbtrans20_qd ;
 electrical f_pmbtrans20_qs ;

 // VPN-Liste deklarieren:
 V(f_pmtrans1_g_t) <+
_a2*$temperature-273.15+300.15-27.0*_a2   ;

 // Vals der Terme s1 ... deklarieren:
  analog function real mysqrt;
      input value;
      real  value;
      if (value >= 0.0)
	 mysqrt = sqrt(value);
      else
	 mysqrt = -sqrt(-value);
  endfunction
 analog begin

 // Vals aus der Val-Liste:
 V(f_pmtrans1_g_ni) <+
0.2788434715e13*pow(V(f_pmtrans1_g_t),1.5)*exp(21.5565981-5802.261235*(1.16-0.702e-3*pow(V(f_pmtrans1_g_t),2)/(V(f_pmtrans1_g_t)+1108.0))/V(f_pmtrans1_g_t))   ;
 V(f_pmtrans1_g_k2) <+
0.4188640132*(1.777177754-0.1312808442e-1*mysqrt(V(f_pmtrans1_g_t)*ln(0.17e24/V(f_pmtrans1_g_ni))))/(0.2625616884e-1*mysqrt(V(f_pmtrans1_g_t)*ln(0.17e24/V(f_pmtrans1_g_ni))*(0.1723466006e-3*V(f_pmtrans1_g_t)*ln(0.17e24/V(f_pmtrans1_g_ni))+5.0))-0.3446932012e-3*V(f_pmtrans1_g_t)*ln(0.17e24/V(f_pmtrans1_g_ni))-5.0)   ;
 V(f_pmtrans1_g_k1) <+
0.6130457498-2.0*V(f_pmtrans1_g_k2)*mysqrt(0.1723466006e-3*V(f_pmtrans1_g_t)*ln(0.17e24/V(f_pmtrans1_g_ni))+5.0)   ;
 V(f_pmtrans1_vgsi) <+
V(u_int1)-1.0*V(vdd)   ;
 V(f_pmtrans1_vdsi) <+
V(u_int1)-1.0*V(vdd)   ;
 V(f_pmtrans1_vbsi) <+
0.0   ;
 V(f_pmtrans1_dir) <+
_a3-1.0*_a3*_a4*(-1.0*V(f_pmtrans1_vdsi) >= 0 ?  1.0 : 0.0 )   ;
 V(f_pmtrans1_vgs) <+
-1.0*(1.0-1.0*V(f_pmtrans1_dir))*V(f_pmtrans1_vgsi)-1.0*V(f_pmtrans1_dir)*(V(f_pmtrans1_vgsi)-1.0*V(f_pmtrans1_vdsi))   ;
 V(f_pmtrans1_vds) <+
-1.0*(1.0-2.0*V(f_pmtrans1_dir))*V(f_pmtrans1_vdsi)   ;
 V(f_pmtrans1_vbs) <+
-1.0*(1.0-1.0*V(f_pmtrans1_dir))*V(f_pmtrans1_vbsi)-1.0*V(f_pmtrans1_dir)*(V(f_pmtrans1_vbsi)-1.0*V(f_pmtrans1_vdsi))   ;
 V(f_pmtrans1_g_y) <+
0.1551119405e-3*V(f_pmtrans1_g_t)*ln(0.17e24/V(f_pmtrans1_g_ni))-0.9*pow(V(f_pmtrans1_g_k1),2)/(4.0*pow(V(f_pmtrans1_g_k2),2)+0.1e-24)   ;
 V(f_pmtrans1_vbc) <+
-8.99925+0.25*V(f_pmtrans1_g_y)+0.25*mysqrt(pow(-29.999-1.0*V(f_pmtrans1_g_y),2)+0.120)-0.5*mysqrt(pow(11.9985-0.5*V(f_pmtrans1_g_y)-0.5*mysqrt(pow(-29.999-1.0*V(f_pmtrans1_g_y),2)+0.120),2)+0.12e-1)   ;
 V(f_pmtrans1_vbseff) <+
_a7*V(f_pmtrans1_vbc)+0.5*_a8*_a7*(V(f_pmtrans1_vbs)-1.0*V(f_pmtrans1_vbc)-0.1e-2+mysqrt(pow(V(f_pmtrans1_vbs)-1.0*V(f_pmtrans1_vbc)-0.1e-2,2)-0.4e-2*V(f_pmtrans1_vbc)))+(1.0-1.0*_a7)*_a8*V(f_pmtrans1_vbs)   ;
 V(f_pmtrans1_sqrtphis) <+
0.1723466006e-3*V(f_pmtrans1_g_t)*ln(0.17e24/V(f_pmtrans1_g_ni))*mysqrt(0.1723466006e-3*V(f_pmtrans1_g_t)*ln(0.17e24/V(f_pmtrans1_g_ni))-1.0*_a5*(0.5*V(f_pmtrans1_vbseff)-0.5*mysqrt(pow(V(f_pmtrans1_vbseff),2))))/(0.1723466006e-3*V(f_pmtrans1_g_t)*ln(0.17e24/V(f_pmtrans1_g_ni))+0.5*_a6*(0.5*V(f_pmtrans1_vbseff)+0.5*mysqrt(pow(V(f_pmtrans1_vbseff),2))))   ;
 V(f_pmtrans1_leff) <+
ota_mbsim3v3_pmtrans1_l   ;
 V(f_pmtrans1_weff_strich) <+
ota_mbsim3v3_pmtrans1_w   ;
 V(f_pmtrans1_leff_cv) <+
ota_mbsim3v3_pmtrans1_l   ;
 V(f_pmtrans1_lt1) <+
0.6264792526e-7*mysqrt(V(f_pmtrans1_sqrtphis))*((-0.32e-1*V(f_pmtrans1_vbseff)+0.5 >= 0 ?  1.0 : 0.0 )*(1.0-0.32e-1*V(f_pmtrans1_vbseff))+1.0*(1.0-1.0*(-0.32e-1*V(f_pmtrans1_vbseff)+0.5 >= 0 ?  1.0 : 0.0 ))*(1.0-0.960e-1*V(f_pmtrans1_vbseff))/(3.0-0.2560*V(f_pmtrans1_vbseff)))   ;
 V(f_pmtrans1_theta0vb0) <+
exp(-69656657.50*V(f_pmtrans1_leff)*pow(V(f_pmtrans1_g_t)*ln(0.17e24/V(f_pmtrans1_g_ni)),-0.2500000000))+2.0*pow(exp(-69656657.50*V(f_pmtrans1_leff)*pow(V(f_pmtrans1_g_t)*ln(0.17e24/V(f_pmtrans1_g_ni)),-0.2500000000)),2)   ;
 V(f_pmtrans1_v0) <+
0.8617330030e-4*V(f_pmtrans1_g_t)*ln(0.17e50*pow(V(f_pmtrans1_g_ni),-2))-0.1723466006e-3*V(f_pmtrans1_g_t)*ln(0.17e24/V(f_pmtrans1_g_ni))   ;
 V(f_pmtrans1_delt_vth) <+
2.2*V(f_pmtrans1_v0)*exp(-0.265*V(f_pmtrans1_leff)/V(f_pmtrans1_lt1))*(1.0+2.0*exp(-0.265*V(f_pmtrans1_leff)/V(f_pmtrans1_lt1)))   ;
 V(f_pmtrans1_vth_t22) <+
0.0   ;
 V(f_pmtrans1_vth_t1_t1) <+
0.1312808442e-1*_a20*V(f_pmtrans1_g_k1)*(mysqrt(1.0+0.174e-6/V(f_pmtrans1_leff))-1.0)*mysqrt(V(f_pmtrans1_g_t)*ln(0.17e24/V(f_pmtrans1_g_ni)))+_a1*(-0.11+0.22e-1*V(f_pmtrans1_vbseff))*(0.3331667500e-2*V(f_pmtrans1_g_t)-1.0)   ;
 V(f_pmtrans1_vth) <+
-1.0*ota_mbsim3v3_p_mos_vth0+_a22*(_a10*(-0.1312808442e-1*V(f_pmtrans1_g_k1)*mysqrt(V(f_pmtrans1_g_t)*ln(0.17e24/V(f_pmtrans1_g_ni)))+1.000000000*V(f_pmtrans1_g_k1)*V(f_pmtrans1_sqrtphis)-1.000000000*V(f_pmtrans1_g_k2)*V(f_pmtrans1_vbseff))-1.0*_a11*V(f_pmtrans1_delt_vth)-1.0*_a11*V(f_pmtrans1_vth_t22)+0.2068159207e-9*V(f_pmtrans1_g_t)*ln(0.17e24/V(f_pmtrans1_g_ni))/(V(f_pmtrans1_weff_strich)+0.25e-5)+V(f_pmtrans1_vth_t1_t1)-1.0*_a17*V(f_pmtrans1_vds)*V(f_pmtrans1_theta0vb0)*(0.8e-1-0.7e-1*V(f_pmtrans1_vbseff)))   ;
 V(f_pmtrans1_scvt) <+
exp(-4229988.446*V(f_pmtrans1_leff)*pow(V(f_pmtrans1_sqrtphis),-0.5000000000)/(1.0-0.32e-1*_a11*V(f_pmtrans1_vbseff)))+2.0*exp(-8459976.892*V(f_pmtrans1_leff)*pow(V(f_pmtrans1_sqrtphis),-0.5000000000)/(1.0-0.32e-1*_a11*V(f_pmtrans1_vbseff)))   ;
 V(f_pmtrans1_nvgs) <+
0.5159548816/V(f_pmtrans1_sqrtphis)+0.1042531521*_a11*V(f_pmtrans1_scvt)   ;
 V(f_pmtrans1_vgsteff) <+
(0.1723466006e-3*_a12*_a13*(V(f_pmtrans1_nvgs)+1.0)*V(f_pmtrans1_g_t)*ln(1.0+exp(5802.261235*(V(f_pmtrans1_vgs)-1.0*V(f_pmtrans1_vth))/(V(f_pmtrans1_nvgs)+1.0)/V(f_pmtrans1_g_t)))+(1.0-1.0*_a12)*_a13*(V(f_pmtrans1_vgs)-1.0*V(f_pmtrans1_vth)))/(1.0+0.5088849782e-1*_a12*_a13*(V(f_pmtrans1_nvgs)+1.0)*mysqrt(V(f_pmtrans1_g_t)*ln(0.17e24/V(f_pmtrans1_g_ni)))*exp(5802.261235*(-1.0*V(f_pmtrans1_vgs)+V(f_pmtrans1_vth)-0.16)/(V(f_pmtrans1_nvgs)+1.0)/V(f_pmtrans1_g_t)))   ;
 V(f_pmtrans1_weff) <+
ota_mbsim3v3_pmtrans1_w   ;
 V(f_pmtrans1_ueff) <+
0.670e-1/(1.0+_a23*(66666666.67*(0.225e-8-0.465e-10*_a10*V(f_pmtrans1_vbseff))*(V(f_pmtrans1_vgsteff)+2.0*V(f_pmtrans1_vth))+0.2608888889e-2*pow(V(f_pmtrans1_vgsteff)+2.0*V(f_pmtrans1_vth),2)))   ;
 V(f_pmtrans1_abulkp) <+
(1.0+0.5000000000*V(f_pmtrans1_g_k1)/V(f_pmtrans1_sqrtphis)*V(f_pmtrans1_leff)/(V(f_pmtrans1_leff)+0.2287578680e-6*mysqrt(V(f_pmtrans1_sqrtphis))))/(1.0-0.47e-1*V(f_pmtrans1_vbseff))   ;
 V(f_pmtrans1_abulk) <+
_a14*(0.5*V(f_pmtrans1_abulkp)+0.245e-1+0.5*mysqrt(pow(V(f_pmtrans1_abulkp)-0.51e-1,2)+0.4e-2))+(1.0-1.0*_a14)*V(f_pmtrans1_abulkp)   ;
 V(f_pmtrans1_temp3) <+
0.160e6*(V(f_pmtrans1_vgsteff)+0.1723466006e-3*_a19*V(f_pmtrans1_g_t))/V(f_pmtrans1_ueff)*V(f_pmtrans1_leff)   ;
 V(f_pmtrans1_temp2) <+
-1.000000000*V(f_pmtrans1_vgsteff)-0.1723466006e-3*_a19*V(f_pmtrans1_g_t)-0.160e6*V(f_pmtrans1_abulk)/V(f_pmtrans1_ueff)*V(f_pmtrans1_leff)   ;
 V(f_pmtrans1_vdsat) <+
0.160e6/V(f_pmtrans1_ueff)*V(f_pmtrans1_leff)*(V(f_pmtrans1_vgsteff)+0.1723466006e-3*_a19*V(f_pmtrans1_g_t))/(0.160e6*V(f_pmtrans1_abulk)/V(f_pmtrans1_ueff)*V(f_pmtrans1_leff)+_a21*(V(f_pmtrans1_vgsteff)+0.1723466006e-3*_a19*V(f_pmtrans1_g_t)))   ;
 V(f_pmtrans1_vdseff) <+
_a16*V(f_pmtrans1_vdsat)-0.5*_a15*_a16*(V(f_pmtrans1_vdsat)-1.0*V(f_pmtrans1_vds)-0.1e-1+mysqrt(pow(V(f_pmtrans1_vdsat)-1.0*V(f_pmtrans1_vds)-0.1e-1,2)+0.4e-1*V(f_pmtrans1_vdsat)))+(1.0-1.0*_a16)*_a15*V(f_pmtrans1_vds)   ;
 V(f_pmtrans1_vasat_t9) <+
0.0   ;
 V(f_pmtrans1_vasat_t0) <+
0.160e6/V(f_pmtrans1_ueff)*V(f_pmtrans1_leff)+V(f_pmtrans1_vdsat)+2.0*V(f_pmtrans1_vasat_t9)*(1.0-0.5*V(f_pmtrans1_abulk)*V(f_pmtrans1_vdsat)/(V(f_pmtrans1_vgsteff)+0.17234174e-3*_a19*V(f_pmtrans1_g_t)))   ;
 V(f_pmtrans1_vasat) <+
1.000000000*V(f_pmtrans1_vasat_t0)   ;
 V(f_pmtrans1_e_vascbe) <+
0.10e-4*_a16/V(f_pmtrans1_leff)*exp(-34.83515634/(V(f_pmtrans1_vds)-1.0*V(f_pmtrans1_vdseff)+0.1e-9))   ;
 V(f_pmtrans1_vadiblc) <+
(V(f_pmtrans1_vgsteff)+0.1723466006e-3*_a19*V(f_pmtrans1_g_t))/(0.39*exp(-39007728.23*V(f_pmtrans1_leff)*pow(V(f_pmtrans1_g_t)*ln(0.17e24/V(f_pmtrans1_g_ni)),-0.2500000000))+0.78*exp(-78015456.46*V(f_pmtrans1_leff)*pow(V(f_pmtrans1_g_t)*ln(0.17e24/V(f_pmtrans1_g_ni)),-0.2500000000))+0.86e-2)*(1.0-1.0*V(f_pmtrans1_abulk)*V(f_pmtrans1_vdsat)/(V(f_pmtrans1_abulk)*V(f_pmtrans1_vdsat)+V(f_pmtrans1_vgsteff)+0.1723466006e-3*_a19*V(f_pmtrans1_g_t)))   ;
 V(f_pmtrans1_vaclm) <+
9362778.307*_a16*V(f_pmtrans1_leff)*(V(f_pmtrans1_abulk)+0.6250000000e-5*_a21*V(f_pmtrans1_vgsteff)*V(f_pmtrans1_ueff)/V(f_pmtrans1_leff))/V(f_pmtrans1_abulk)*(V(f_pmtrans1_vds)-1.0*V(f_pmtrans1_vdseff)+0.1e-9)+0.1e-9-0.1e-9*_a16   ;
 V(f_pmtrans1_vafaktor) <+
_a17*_a18/(1.0/V(f_pmtrans1_vaclm)+1.0/V(f_pmtrans1_vadiblc))+(1.0-1.0*_a17)*_a18*V(f_pmtrans1_vaclm)+_a17*(1.0-1.0*_a18)*V(f_pmtrans1_vadiblc)   ;
 V(f_pmtrans1_va) <+
V(f_pmtrans1_vasat)+V(f_pmtrans1_vafaktor)   ;
 V(f_pmtrans1_idso) <+
0.2302088667e-2*V(f_pmtrans1_weff)*V(f_pmtrans1_ueff)*V(f_pmtrans1_vgsteff)*(1.0-1.0*V(f_pmtrans1_abulk)*V(f_pmtrans1_vdseff)/(2.0*V(f_pmtrans1_vgsteff)+0.3446932012e-3*_a19*V(f_pmtrans1_g_t)))*V(f_pmtrans1_vdseff)/V(f_pmtrans1_leff)/(1.0+0.6250000000e-5*_a21*V(f_pmtrans1_vdseff)*V(f_pmtrans1_ueff)/V(f_pmtrans1_leff))   ;
 V(f_pmtrans1_idsx) <+
V(f_pmtrans1_idso)*(1.0+_a16*_a9*(V(f_pmtrans1_vds)-1.0*V(f_pmtrans1_vdseff))*V(f_pmtrans1_e_vascbe))*(1.0+_a16*(_a17+_a18-0.5 >= 0 ?  1.0 : 0.0 )*(V(f_pmtrans1_vds)-1.0*V(f_pmtrans1_vdseff))/V(f_pmtrans1_va))   ;
 V(f_pmtrans1_ids) <+
(1.0-2.0*V(f_pmtrans1_dir))*V(f_pmtrans1_idsx)   ;
 V(f_pmtrans1_cgdo_strich) <+
0.2801776464e-9*ota_mbsim3v3_pmtrans1_w   ;
 V(f_pmtrans1_cgso_strich) <+
0.2801776464e-9*ota_mbsim3v3_pmtrans1_w   ;
 V(f_pmtrans1_echte_vgd) <+
-1.0*V(f_pmtrans1_vgsi)+V(f_pmtrans1_vdsi)   ;
 V(f_pmtrans1_echte_vgs) <+
-1.0*V(f_pmtrans1_vgsi)   ;
 V(f_pmtrans1_echte_vgb) <+
-1.0*V(f_pmtrans1_vgsi)+V(f_pmtrans1_vbsi)   ;
 V(f_pmtrans1_qgdo_T0) <+
V(f_pmtrans1_echte_vgd)+0.2e-1   ;
 V(f_pmtrans1_qgdo_T1) <+
mysqrt(pow(V(f_pmtrans1_qgdo_T0),2)+0.8e-1)   ;
 V(f_pmtrans1_qgdo_T2) <+
0.5*V(f_pmtrans1_qgdo_T0)-0.5*V(f_pmtrans1_qgdo_T1)   ;
 V(f_pmtrans1_qgdo_T3) <+
0.0   ;
 V(f_pmtrans1_qgdo_T4) <+
mysqrt(1.0-6.666666668*V(f_pmtrans1_qgdo_T2))   ;
 V(f_pmtrans1_qgso_T0) <+
V(f_pmtrans1_echte_vgs)+0.2e-1   ;
 V(f_pmtrans1_qgso_T1) <+
mysqrt(pow(V(f_pmtrans1_qgso_T0),2)+0.8e-1)   ;
 V(f_pmtrans1_qgso_T2) <+
0.5*V(f_pmtrans1_qgso_T0)-0.5*V(f_pmtrans1_qgso_T1)   ;
 V(f_pmtrans1_qgso_T3) <+
0.0   ;
 V(f_pmtrans1_qgso_T4) <+
mysqrt(1.0-6.666666668*V(f_pmtrans1_qgso_T2))   ;
 V(f_pmtrans1_qoverlap_d) <+
(V(f_pmtrans1_cgdo_strich)+V(f_pmtrans1_qgdo_T3))*V(f_pmtrans1_echte_vgd)-1.0*V(f_pmtrans1_qgdo_T3)*(V(f_pmtrans1_qgdo_T2)+0.30*V(f_pmtrans1_qgdo_T4)-0.300)   ;
 V(f_pmtrans1_qoverlap_s) <+
(V(f_pmtrans1_cgso_strich)+V(f_pmtrans1_qgso_T3))*V(f_pmtrans1_echte_vgs)-1.0*V(f_pmtrans1_qgso_T3)*(V(f_pmtrans1_qgso_T2)+0.30*V(f_pmtrans1_qgso_T4)-0.300)   ;
 V(f_pmtrans1_v3) <+
-1.0*ota_mbsim3v3_p_mos_vth0-0.1723466006e-3*V(f_pmtrans1_g_t)*ln(0.17e24/V(f_pmtrans1_g_ni))-0.1312808442e-1*V(f_pmtrans1_g_k1)*mysqrt(V(f_pmtrans1_g_t)*ln(0.17e24/V(f_pmtrans1_g_ni)))-1.0*V(f_pmtrans1_vgs)+V(f_pmtrans1_vbseff)-0.2e-1   ;
 V(f_pmtrans1_vfbeff) <+
-1.0*ota_mbsim3v3_p_mos_vth0-0.1723466006e-3*V(f_pmtrans1_g_t)*ln(0.17e24/V(f_pmtrans1_g_ni))-0.1312808442e-1*V(f_pmtrans1_g_k1)*mysqrt(V(f_pmtrans1_g_t)*ln(0.17e24/V(f_pmtrans1_g_ni)))-0.5*V(f_pmtrans1_v3)-0.5*mysqrt(pow(V(f_pmtrans1_v3),2)+0.8e-1*mysqrt(pow(-1.0*ota_mbsim3v3_p_mos_vth0-0.1723466006e-3*V(f_pmtrans1_g_t)*ln(0.17e24/V(f_pmtrans1_g_ni))-0.1312808442e-1*V(f_pmtrans1_g_k1)*mysqrt(V(f_pmtrans1_g_t)*ln(0.17e24/V(f_pmtrans1_g_ni))),2)))   ;
 V(f_pmtrans1_qac0) <+
0.2302088667e-2*ota_mbsim3v3_pmtrans1_w*V(f_pmtrans1_leff_cv)*(V(f_pmtrans1_vfbeff)+ota_mbsim3v3_p_mos_vth0+0.1723466006e-3*V(f_pmtrans1_g_t)*ln(0.17e24/V(f_pmtrans1_g_ni))+0.1312808442e-1*V(f_pmtrans1_g_k1)*mysqrt(V(f_pmtrans1_g_t)*ln(0.17e24/V(f_pmtrans1_g_ni))))   ;
 V(f_pmtrans1_abulk_cv) <+
(0.5*(1.0+0.5000000000*V(f_pmtrans1_g_k1)/V(f_pmtrans1_sqrtphis)*V(f_pmtrans1_leff)/(V(f_pmtrans1_leff)+0.2287578680e-6*mysqrt(V(f_pmtrans1_sqrtphis))))/(1.0-0.47e-1*V(f_pmtrans1_vbseff))+0.245e-1+0.5*mysqrt(pow((1.0+0.5000000000*V(f_pmtrans1_g_k1)/V(f_pmtrans1_sqrtphis)*V(f_pmtrans1_leff)/(V(f_pmtrans1_leff)+0.2287578680e-6*mysqrt(V(f_pmtrans1_sqrtphis))))/(1.0-0.47e-1*V(f_pmtrans1_vbseff))-0.51e-1,2)+0.4e-2))*(1.0+0.6309573445e-4*pow(1.0/V(f_pmtrans1_leff),0.6))   ;
 V(f_pmtrans1_vdsat_cv) <+
V(f_pmtrans1_vgsteff)/V(f_pmtrans1_abulk_cv)   ;
 V(f_pmtrans1_qsub0) <+
0.2302088667e-2*ota_mbsim3v3_pmtrans1_w*V(f_pmtrans1_leff_cv)*V(f_pmtrans1_g_k1)*(pow(pow(0.2500000000*pow(V(f_pmtrans1_g_k1),2)+0.5*V(f_pmtrans1_vgs)-0.5*V(f_pmtrans1_vfbeff)-0.5*V(f_pmtrans1_vgsteff)-0.5*V(f_pmtrans1_vbseff)+0.5*mysqrt(pow(V(f_pmtrans1_vgs)-1.0*V(f_pmtrans1_vfbeff)-1.0*V(f_pmtrans1_vgsteff)-1.0*V(f_pmtrans1_vbseff),2)),2),0.2500000000)+0.5*V(f_pmtrans1_vgs)-0.5*V(f_pmtrans1_vfbeff)-0.5*V(f_pmtrans1_vgsteff)-0.5*V(f_pmtrans1_vbseff)-0.5*mysqrt(pow(V(f_pmtrans1_vgs)-1.0*V(f_pmtrans1_vfbeff)-1.0*V(f_pmtrans1_vgsteff)-1.0*V(f_pmtrans1_vbseff),2))-0.5000000000*V(f_pmtrans1_g_k1))   ;
 V(f_pmtrans1_vdseff_cv) <+
0.5*V(f_pmtrans1_vdsat_cv)+0.5*V(f_pmtrans1_vds)+0.10e-1-0.5*mysqrt(pow(V(f_pmtrans1_vdsat_cv)-1.0*V(f_pmtrans1_vds)-0.2e-1,2)+0.8e-1*V(f_pmtrans1_vdsat_cv))   ;
 V(f_pmtrans1_faktor_t1) <+
12.0*V(f_pmtrans1_vgsteff)-6.0*V(f_pmtrans1_abulk_cv)*V(f_pmtrans1_vdseff_cv)+0.12e-18   ;
 V(f_pmtrans1_qs_ohne_o) <+
-0.1151044334e-2*ota_mbsim3v3_pmtrans1_w*V(f_pmtrans1_leff_cv)*(V(f_pmtrans1_vgsteff)-0.5*V(f_pmtrans1_vdseff_cv)+V(f_pmtrans1_abulk_cv)*pow(V(f_pmtrans1_vdseff_cv),2)/V(f_pmtrans1_faktor_t1))-0.1151044334e-2*ota_mbsim3v3_pmtrans1_w*V(f_pmtrans1_leff_cv)*(1.0-1.0*V(f_pmtrans1_abulk_cv))*(0.5*V(f_pmtrans1_vdseff_cv)-1.0*V(f_pmtrans1_abulk_cv)*pow(V(f_pmtrans1_vdseff_cv),2)/V(f_pmtrans1_faktor_t1))   ;
 V(f_pmtrans1_g_qg) <+
0.2302088667e-2*ota_mbsim3v3_pmtrans1_w*V(f_pmtrans1_leff_cv)*(V(f_pmtrans1_vgsteff)-0.5*V(f_pmtrans1_vdseff_cv)+V(f_pmtrans1_abulk_cv)*pow(V(f_pmtrans1_vdseff_cv),2)/V(f_pmtrans1_faktor_t1))+V(f_pmtrans1_qac0)+V(f_pmtrans1_qsub0)   ;
 V(f_pmtrans1_qg) <+
V(f_pmtrans1_g_qg)+V(f_pmtrans1_qoverlap_s)+V(f_pmtrans1_qoverlap_d)   ;
 V(f_pmtrans1_g_qb) <+
0.2302088667e-2*ota_mbsim3v3_pmtrans1_w*V(f_pmtrans1_leff_cv)*(1.0-1.0*V(f_pmtrans1_abulk_cv))*(0.5*V(f_pmtrans1_vdseff_cv)-1.0*V(f_pmtrans1_abulk_cv)*pow(V(f_pmtrans1_vdseff_cv),2)/V(f_pmtrans1_faktor_t1))-1.0*V(f_pmtrans1_qac0)-1.0*V(f_pmtrans1_qsub0)   ;
 V(f_pmtrans1_qb) <+
V(f_pmtrans1_g_qb)   ;
 V(f_pmtrans1_g_qd) <+
-1.0*V(f_pmtrans1_g_qg)-1.0*V(f_pmtrans1_qs_ohne_o)-1.0*V(f_pmtrans1_g_qb)   ;
 V(f_pmtrans1_qd) <+
(1.0-1.0*V(f_pmtrans1_dir))*(V(f_pmtrans1_g_qd)-1.0*V(f_pmtrans1_qoverlap_d))+V(f_pmtrans1_dir)*(V(f_pmtrans1_qs_ohne_o)-1.0*V(f_pmtrans1_qoverlap_d))   ;
 V(f_pmtrans1_qs) <+
(1.0-1.0*V(f_pmtrans1_dir))*(V(f_pmtrans1_qs_ohne_o)-1.0*V(f_pmtrans1_qoverlap_s))+V(f_pmtrans1_dir)*(V(f_pmtrans1_g_qd)-1.0*V(f_pmtrans1_qoverlap_s))   ;
 V(f_pmtrans2_g_t) <+
_a26*$temperature-273.15+300.15-27.0*_a26   ;
 V(f_pmtrans2_g_ni) <+
0.2788434715e13*pow(V(f_pmtrans2_g_t),1.5)*exp(21.5565981-5802.261235*(1.16-0.702e-3*pow(V(f_pmtrans2_g_t),2)/(V(f_pmtrans2_g_t)+1108.0))/V(f_pmtrans2_g_t))   ;
 V(f_pmtrans2_g_k2) <+
0.4188640132*(1.777177754-0.1312808442e-1*mysqrt(V(f_pmtrans2_g_t)*ln(0.17e24/V(f_pmtrans2_g_ni))))/(0.2625616884e-1*mysqrt(V(f_pmtrans2_g_t)*ln(0.17e24/V(f_pmtrans2_g_ni))*(0.1723466006e-3*V(f_pmtrans2_g_t)*ln(0.17e24/V(f_pmtrans2_g_ni))+5.0))-0.3446932012e-3*V(f_pmtrans2_g_t)*ln(0.17e24/V(f_pmtrans2_g_ni))-5.0)   ;
 V(f_pmtrans2_g_k1) <+
0.6130457498-2.0*V(f_pmtrans2_g_k2)*mysqrt(0.1723466006e-3*V(f_pmtrans2_g_t)*ln(0.17e24/V(f_pmtrans2_g_ni))+5.0)   ;
 V(f_pmtrans2_vgsi) <+
V(u_int1)-1.0*V(vdd)   ;
 V(f_pmtrans2_vdsi) <+
V(out1)-1.0*V(vdd)   ;
 V(f_pmtrans2_vbsi) <+
0.0   ;
 V(f_pmtrans2_dir) <+
_a27-1.0*_a27*_a28*(-1.0*V(f_pmtrans2_vdsi) >= 0 ?  1.0 : 0.0 )   ;
 V(f_pmtrans2_vgs) <+
-1.0*(1.0-1.0*V(f_pmtrans2_dir))*V(f_pmtrans2_vgsi)-1.0*V(f_pmtrans2_dir)*(V(f_pmtrans2_vgsi)-1.0*V(f_pmtrans2_vdsi))   ;
 V(f_pmtrans2_vds) <+
-1.0*(1.0-2.0*V(f_pmtrans2_dir))*V(f_pmtrans2_vdsi)   ;
 V(f_pmtrans2_vbs) <+
-1.0*(1.0-1.0*V(f_pmtrans2_dir))*V(f_pmtrans2_vbsi)-1.0*V(f_pmtrans2_dir)*(V(f_pmtrans2_vbsi)-1.0*V(f_pmtrans2_vdsi))   ;
 V(f_pmtrans2_g_y) <+
0.1551119405e-3*V(f_pmtrans2_g_t)*ln(0.17e24/V(f_pmtrans2_g_ni))-0.9*pow(V(f_pmtrans2_g_k1),2)/(4.0*pow(V(f_pmtrans2_g_k2),2)+0.1e-24)   ;
 V(f_pmtrans2_vbc) <+
-8.99925+0.25*V(f_pmtrans2_g_y)+0.25*mysqrt(pow(-29.999-1.0*V(f_pmtrans2_g_y),2)+0.120)-0.5*mysqrt(pow(11.9985-0.5*V(f_pmtrans2_g_y)-0.5*mysqrt(pow(-29.999-1.0*V(f_pmtrans2_g_y),2)+0.120),2)+0.12e-1)   ;
 V(f_pmtrans2_vbseff) <+
_a31*V(f_pmtrans2_vbc)+0.5*_a32*_a31*(V(f_pmtrans2_vbs)-1.0*V(f_pmtrans2_vbc)-0.1e-2+mysqrt(pow(V(f_pmtrans2_vbs)-1.0*V(f_pmtrans2_vbc)-0.1e-2,2)-0.4e-2*V(f_pmtrans2_vbc)))+(1.0-1.0*_a31)*_a32*V(f_pmtrans2_vbs)   ;
 V(f_pmtrans2_sqrtphis) <+
0.1723466006e-3*V(f_pmtrans2_g_t)*ln(0.17e24/V(f_pmtrans2_g_ni))*mysqrt(0.1723466006e-3*V(f_pmtrans2_g_t)*ln(0.17e24/V(f_pmtrans2_g_ni))-1.0*_a29*(0.5*V(f_pmtrans2_vbseff)-0.5*mysqrt(pow(V(f_pmtrans2_vbseff),2))))/(0.1723466006e-3*V(f_pmtrans2_g_t)*ln(0.17e24/V(f_pmtrans2_g_ni))+0.5*_a30*(0.5*V(f_pmtrans2_vbseff)+0.5*mysqrt(pow(V(f_pmtrans2_vbseff),2))))   ;
 V(f_pmtrans2_leff) <+
ota_mbsim3v3_pmtrans2_l   ;
 V(f_pmtrans2_weff_strich) <+
ota_mbsim3v3_pmtrans2_w   ;
 V(f_pmtrans2_leff_cv) <+
ota_mbsim3v3_pmtrans2_l   ;
 V(f_pmtrans2_lt1) <+
0.6264792526e-7*mysqrt(V(f_pmtrans2_sqrtphis))*((-0.32e-1*V(f_pmtrans2_vbseff)+0.5 >= 0 ?  1.0 : 0.0 )*(1.0-0.32e-1*V(f_pmtrans2_vbseff))+1.0*(1.0-1.0*(-0.32e-1*V(f_pmtrans2_vbseff)+0.5 >= 0 ?  1.0 : 0.0 ))*(1.0-0.960e-1*V(f_pmtrans2_vbseff))/(3.0-0.2560*V(f_pmtrans2_vbseff)))   ;
 V(f_pmtrans2_theta0vb0) <+
exp(-69656657.50*V(f_pmtrans2_leff)*pow(V(f_pmtrans2_g_t)*ln(0.17e24/V(f_pmtrans2_g_ni)),-0.2500000000))+2.0*pow(exp(-69656657.50*V(f_pmtrans2_leff)*pow(V(f_pmtrans2_g_t)*ln(0.17e24/V(f_pmtrans2_g_ni)),-0.2500000000)),2)   ;
 V(f_pmtrans2_v0) <+
0.8617330030e-4*V(f_pmtrans2_g_t)*ln(0.17e50*pow(V(f_pmtrans2_g_ni),-2))-0.1723466006e-3*V(f_pmtrans2_g_t)*ln(0.17e24/V(f_pmtrans2_g_ni))   ;
 V(f_pmtrans2_delt_vth) <+
2.2*V(f_pmtrans2_v0)*exp(-0.265*V(f_pmtrans2_leff)/V(f_pmtrans2_lt1))*(1.0+2.0*exp(-0.265*V(f_pmtrans2_leff)/V(f_pmtrans2_lt1)))   ;
 V(f_pmtrans2_vth_t22) <+
0.0   ;
 V(f_pmtrans2_vth_t1_t1) <+
0.1312808442e-1*_a44*V(f_pmtrans2_g_k1)*(mysqrt(1.0+0.174e-6/V(f_pmtrans2_leff))-1.0)*mysqrt(V(f_pmtrans2_g_t)*ln(0.17e24/V(f_pmtrans2_g_ni)))+_a25*(-0.11+0.22e-1*V(f_pmtrans2_vbseff))*(0.3331667500e-2*V(f_pmtrans2_g_t)-1.0)   ;
 V(f_pmtrans2_vth) <+
-1.0*ota_mbsim3v3_p_mos_vth0+_a46*(_a34*(-0.1312808442e-1*V(f_pmtrans2_g_k1)*mysqrt(V(f_pmtrans2_g_t)*ln(0.17e24/V(f_pmtrans2_g_ni)))+1.000000000*V(f_pmtrans2_g_k1)*V(f_pmtrans2_sqrtphis)-1.000000000*V(f_pmtrans2_g_k2)*V(f_pmtrans2_vbseff))-1.0*_a35*V(f_pmtrans2_delt_vth)-1.0*_a35*V(f_pmtrans2_vth_t22)+0.2068159207e-9*V(f_pmtrans2_g_t)*ln(0.17e24/V(f_pmtrans2_g_ni))/(V(f_pmtrans2_weff_strich)+0.25e-5)+V(f_pmtrans2_vth_t1_t1)-1.0*_a41*V(f_pmtrans2_vds)*V(f_pmtrans2_theta0vb0)*(0.8e-1-0.7e-1*V(f_pmtrans2_vbseff)))   ;
 V(f_pmtrans2_scvt) <+
exp(-4229988.446*V(f_pmtrans2_leff)*pow(V(f_pmtrans2_sqrtphis),-0.5000000000)/(1.0-0.32e-1*_a35*V(f_pmtrans2_vbseff)))+2.0*exp(-8459976.892*V(f_pmtrans2_leff)*pow(V(f_pmtrans2_sqrtphis),-0.5000000000)/(1.0-0.32e-1*_a35*V(f_pmtrans2_vbseff)))   ;
 V(f_pmtrans2_nvgs) <+
0.5159548816/V(f_pmtrans2_sqrtphis)+0.1042531521*_a35*V(f_pmtrans2_scvt)   ;
 V(f_pmtrans2_vgsteff) <+
(0.1723466006e-3*_a36*_a37*(V(f_pmtrans2_nvgs)+1.0)*V(f_pmtrans2_g_t)*ln(1.0+exp(5802.261235*(V(f_pmtrans2_vgs)-1.0*V(f_pmtrans2_vth))/(V(f_pmtrans2_nvgs)+1.0)/V(f_pmtrans2_g_t)))+(1.0-1.0*_a36)*_a37*(V(f_pmtrans2_vgs)-1.0*V(f_pmtrans2_vth)))/(1.0+0.5088849782e-1*_a36*_a37*(V(f_pmtrans2_nvgs)+1.0)*mysqrt(V(f_pmtrans2_g_t)*ln(0.17e24/V(f_pmtrans2_g_ni)))*exp(5802.261235*(-1.0*V(f_pmtrans2_vgs)+V(f_pmtrans2_vth)-0.16)/(V(f_pmtrans2_nvgs)+1.0)/V(f_pmtrans2_g_t)))   ;
 V(f_pmtrans2_weff) <+
ota_mbsim3v3_pmtrans2_w   ;
 V(f_pmtrans2_ueff) <+
0.670e-1/(1.0+_a47*(66666666.67*(0.225e-8-0.465e-10*_a34*V(f_pmtrans2_vbseff))*(V(f_pmtrans2_vgsteff)+2.0*V(f_pmtrans2_vth))+0.2608888889e-2*pow(V(f_pmtrans2_vgsteff)+2.0*V(f_pmtrans2_vth),2)))   ;
 V(f_pmtrans2_abulkp) <+
(1.0+0.5000000000*V(f_pmtrans2_g_k1)/V(f_pmtrans2_sqrtphis)*V(f_pmtrans2_leff)/(V(f_pmtrans2_leff)+0.2287578680e-6*mysqrt(V(f_pmtrans2_sqrtphis))))/(1.0-0.47e-1*V(f_pmtrans2_vbseff))   ;
 V(f_pmtrans2_abulk) <+
_a38*(0.5*V(f_pmtrans2_abulkp)+0.245e-1+0.5*mysqrt(pow(V(f_pmtrans2_abulkp)-0.51e-1,2)+0.4e-2))+(1.0-1.0*_a38)*V(f_pmtrans2_abulkp)   ;
 V(f_pmtrans2_temp3) <+
0.160e6*(V(f_pmtrans2_vgsteff)+0.1723466006e-3*_a43*V(f_pmtrans2_g_t))/V(f_pmtrans2_ueff)*V(f_pmtrans2_leff)   ;
 V(f_pmtrans2_temp2) <+
-1.000000000*V(f_pmtrans2_vgsteff)-0.1723466006e-3*_a43*V(f_pmtrans2_g_t)-0.160e6*V(f_pmtrans2_abulk)/V(f_pmtrans2_ueff)*V(f_pmtrans2_leff)   ;
 V(f_pmtrans2_vdsat) <+
0.160e6/V(f_pmtrans2_ueff)*V(f_pmtrans2_leff)*(V(f_pmtrans2_vgsteff)+0.1723466006e-3*_a43*V(f_pmtrans2_g_t))/(0.160e6*V(f_pmtrans2_abulk)/V(f_pmtrans2_ueff)*V(f_pmtrans2_leff)+_a45*(V(f_pmtrans2_vgsteff)+0.1723466006e-3*_a43*V(f_pmtrans2_g_t)))   ;
 V(f_pmtrans2_vdseff) <+
_a40*V(f_pmtrans2_vdsat)-0.5*_a39*_a40*(V(f_pmtrans2_vdsat)-1.0*V(f_pmtrans2_vds)-0.1e-1+mysqrt(pow(V(f_pmtrans2_vdsat)-1.0*V(f_pmtrans2_vds)-0.1e-1,2)+0.4e-1*V(f_pmtrans2_vdsat)))+(1.0-1.0*_a40)*_a39*V(f_pmtrans2_vds)   ;
 V(f_pmtrans2_vasat_t9) <+
0.0   ;
 V(f_pmtrans2_vasat_t0) <+
0.160e6/V(f_pmtrans2_ueff)*V(f_pmtrans2_leff)+V(f_pmtrans2_vdsat)+2.0*V(f_pmtrans2_vasat_t9)*(1.0-0.5*V(f_pmtrans2_abulk)*V(f_pmtrans2_vdsat)/(V(f_pmtrans2_vgsteff)+0.17234174e-3*_a43*V(f_pmtrans2_g_t)))   ;
 V(f_pmtrans2_vasat) <+
1.000000000*V(f_pmtrans2_vasat_t0)   ;
 V(f_pmtrans2_e_vascbe) <+
0.10e-4*_a40/V(f_pmtrans2_leff)*exp(-34.83515634/(V(f_pmtrans2_vds)-1.0*V(f_pmtrans2_vdseff)+0.1e-9))   ;
 V(f_pmtrans2_vadiblc) <+
(V(f_pmtrans2_vgsteff)+0.1723466006e-3*_a43*V(f_pmtrans2_g_t))/(0.39*exp(-39007728.23*V(f_pmtrans2_leff)*pow(V(f_pmtrans2_g_t)*ln(0.17e24/V(f_pmtrans2_g_ni)),-0.2500000000))+0.78*exp(-78015456.46*V(f_pmtrans2_leff)*pow(V(f_pmtrans2_g_t)*ln(0.17e24/V(f_pmtrans2_g_ni)),-0.2500000000))+0.86e-2)*(1.0-1.0*V(f_pmtrans2_abulk)*V(f_pmtrans2_vdsat)/(V(f_pmtrans2_abulk)*V(f_pmtrans2_vdsat)+V(f_pmtrans2_vgsteff)+0.1723466006e-3*_a43*V(f_pmtrans2_g_t)))   ;
 V(f_pmtrans2_vaclm) <+
9362778.307*_a40*V(f_pmtrans2_leff)*(V(f_pmtrans2_abulk)+0.6250000000e-5*_a45*V(f_pmtrans2_vgsteff)*V(f_pmtrans2_ueff)/V(f_pmtrans2_leff))/V(f_pmtrans2_abulk)*(V(f_pmtrans2_vds)-1.0*V(f_pmtrans2_vdseff)+0.1e-9)+0.1e-9-0.1e-9*_a40   ;
 V(f_pmtrans2_vafaktor) <+
_a41*_a42/(1.0/V(f_pmtrans2_vaclm)+1.0/V(f_pmtrans2_vadiblc))+(1.0-1.0*_a41)*_a42*V(f_pmtrans2_vaclm)+_a41*(1.0-1.0*_a42)*V(f_pmtrans2_vadiblc)   ;
 V(f_pmtrans2_va) <+
V(f_pmtrans2_vasat)+V(f_pmtrans2_vafaktor)   ;
 V(f_pmtrans2_idso) <+
0.2302088667e-2*V(f_pmtrans2_weff)*V(f_pmtrans2_ueff)*V(f_pmtrans2_vgsteff)*(1.0-1.0*V(f_pmtrans2_abulk)*V(f_pmtrans2_vdseff)/(2.0*V(f_pmtrans2_vgsteff)+0.3446932012e-3*_a43*V(f_pmtrans2_g_t)))*V(f_pmtrans2_vdseff)/V(f_pmtrans2_leff)/(1.0+0.6250000000e-5*_a45*V(f_pmtrans2_vdseff)*V(f_pmtrans2_ueff)/V(f_pmtrans2_leff))   ;
 V(f_pmtrans2_idsx) <+
V(f_pmtrans2_idso)*(1.0+_a40*_a33*(V(f_pmtrans2_vds)-1.0*V(f_pmtrans2_vdseff))*V(f_pmtrans2_e_vascbe))*(1.0+_a40*(_a41+_a42-0.5 >= 0 ?  1.0 : 0.0 )*(V(f_pmtrans2_vds)-1.0*V(f_pmtrans2_vdseff))/V(f_pmtrans2_va))   ;
 V(f_pmtrans2_ids) <+
(1.0-2.0*V(f_pmtrans2_dir))*V(f_pmtrans2_idsx)   ;
 V(f_pmtrans2_cgdo_strich) <+
0.2801776464e-9*ota_mbsim3v3_pmtrans2_w   ;
 V(f_pmtrans2_cgso_strich) <+
0.2801776464e-9*ota_mbsim3v3_pmtrans2_w   ;
 V(f_pmtrans2_echte_vgd) <+
-1.0*V(f_pmtrans2_vgsi)+V(f_pmtrans2_vdsi)   ;
 V(f_pmtrans2_echte_vgs) <+
-1.0*V(f_pmtrans2_vgsi)   ;
 V(f_pmtrans2_echte_vgb) <+
-1.0*V(f_pmtrans2_vgsi)+V(f_pmtrans2_vbsi)   ;
 V(f_pmtrans2_qgdo_T0) <+
V(f_pmtrans2_echte_vgd)+0.2e-1   ;
 V(f_pmtrans2_qgdo_T1) <+
mysqrt(pow(V(f_pmtrans2_qgdo_T0),2)+0.8e-1)   ;
 V(f_pmtrans2_qgdo_T2) <+
0.5*V(f_pmtrans2_qgdo_T0)-0.5*V(f_pmtrans2_qgdo_T1)   ;
 V(f_pmtrans2_qgdo_T3) <+
0.0   ;
 V(f_pmtrans2_qgdo_T4) <+
mysqrt(1.0-6.666666668*V(f_pmtrans2_qgdo_T2))   ;
 V(f_pmtrans2_qgso_T0) <+
V(f_pmtrans2_echte_vgs)+0.2e-1   ;
 V(f_pmtrans2_qgso_T1) <+
mysqrt(pow(V(f_pmtrans2_qgso_T0),2)+0.8e-1)   ;
 V(f_pmtrans2_qgso_T2) <+
0.5*V(f_pmtrans2_qgso_T0)-0.5*V(f_pmtrans2_qgso_T1)   ;
 V(f_pmtrans2_qgso_T3) <+
0.0   ;
 V(f_pmtrans2_qgso_T4) <+
mysqrt(1.0-6.666666668*V(f_pmtrans2_qgso_T2))   ;
 V(f_pmtrans2_qoverlap_d) <+
(V(f_pmtrans2_cgdo_strich)+V(f_pmtrans2_qgdo_T3))*V(f_pmtrans2_echte_vgd)-1.0*V(f_pmtrans2_qgdo_T3)*(V(f_pmtrans2_qgdo_T2)+0.30*V(f_pmtrans2_qgdo_T4)-0.300)   ;
 V(f_pmtrans2_qoverlap_s) <+
(V(f_pmtrans2_cgso_strich)+V(f_pmtrans2_qgso_T3))*V(f_pmtrans2_echte_vgs)-1.0*V(f_pmtrans2_qgso_T3)*(V(f_pmtrans2_qgso_T2)+0.30*V(f_pmtrans2_qgso_T4)-0.300)   ;
 V(f_pmtrans2_v3) <+
-1.0*ota_mbsim3v3_p_mos_vth0-0.1723466006e-3*V(f_pmtrans2_g_t)*ln(0.17e24/V(f_pmtrans2_g_ni))-0.1312808442e-1*V(f_pmtrans2_g_k1)*mysqrt(V(f_pmtrans2_g_t)*ln(0.17e24/V(f_pmtrans2_g_ni)))-1.0*V(f_pmtrans2_vgs)+V(f_pmtrans2_vbseff)-0.2e-1   ;
 V(f_pmtrans2_vfbeff) <+
-1.0*ota_mbsim3v3_p_mos_vth0-0.1723466006e-3*V(f_pmtrans2_g_t)*ln(0.17e24/V(f_pmtrans2_g_ni))-0.1312808442e-1*V(f_pmtrans2_g_k1)*mysqrt(V(f_pmtrans2_g_t)*ln(0.17e24/V(f_pmtrans2_g_ni)))-0.5*V(f_pmtrans2_v3)-0.5*mysqrt(pow(V(f_pmtrans2_v3),2)+0.8e-1*mysqrt(pow(-1.0*ota_mbsim3v3_p_mos_vth0-0.1723466006e-3*V(f_pmtrans2_g_t)*ln(0.17e24/V(f_pmtrans2_g_ni))-0.1312808442e-1*V(f_pmtrans2_g_k1)*mysqrt(V(f_pmtrans2_g_t)*ln(0.17e24/V(f_pmtrans2_g_ni))),2)))   ;
 V(f_pmtrans2_qac0) <+
0.2302088667e-2*ota_mbsim3v3_pmtrans2_w*V(f_pmtrans2_leff_cv)*(V(f_pmtrans2_vfbeff)+ota_mbsim3v3_p_mos_vth0+0.1723466006e-3*V(f_pmtrans2_g_t)*ln(0.17e24/V(f_pmtrans2_g_ni))+0.1312808442e-1*V(f_pmtrans2_g_k1)*mysqrt(V(f_pmtrans2_g_t)*ln(0.17e24/V(f_pmtrans2_g_ni))))   ;
 V(f_pmtrans2_abulk_cv) <+
(0.5*(1.0+0.5000000000*V(f_pmtrans2_g_k1)/V(f_pmtrans2_sqrtphis)*V(f_pmtrans2_leff)/(V(f_pmtrans2_leff)+0.2287578680e-6*mysqrt(V(f_pmtrans2_sqrtphis))))/(1.0-0.47e-1*V(f_pmtrans2_vbseff))+0.245e-1+0.5*mysqrt(pow((1.0+0.5000000000*V(f_pmtrans2_g_k1)/V(f_pmtrans2_sqrtphis)*V(f_pmtrans2_leff)/(V(f_pmtrans2_leff)+0.2287578680e-6*mysqrt(V(f_pmtrans2_sqrtphis))))/(1.0-0.47e-1*V(f_pmtrans2_vbseff))-0.51e-1,2)+0.4e-2))*(1.0+0.6309573445e-4*pow(1.0/V(f_pmtrans2_leff),0.6))   ;
 V(f_pmtrans2_vdsat_cv) <+
V(f_pmtrans2_vgsteff)/V(f_pmtrans2_abulk_cv)   ;
 V(f_pmtrans2_qsub0) <+
0.2302088667e-2*ota_mbsim3v3_pmtrans2_w*V(f_pmtrans2_leff_cv)*V(f_pmtrans2_g_k1)*(pow(pow(0.2500000000*pow(V(f_pmtrans2_g_k1),2)+0.5*V(f_pmtrans2_vgs)-0.5*V(f_pmtrans2_vfbeff)-0.5*V(f_pmtrans2_vgsteff)-0.5*V(f_pmtrans2_vbseff)+0.5*mysqrt(pow(V(f_pmtrans2_vgs)-1.0*V(f_pmtrans2_vfbeff)-1.0*V(f_pmtrans2_vgsteff)-1.0*V(f_pmtrans2_vbseff),2)),2),0.2500000000)+0.5*V(f_pmtrans2_vgs)-0.5*V(f_pmtrans2_vfbeff)-0.5*V(f_pmtrans2_vgsteff)-0.5*V(f_pmtrans2_vbseff)-0.5*mysqrt(pow(V(f_pmtrans2_vgs)-1.0*V(f_pmtrans2_vfbeff)-1.0*V(f_pmtrans2_vgsteff)-1.0*V(f_pmtrans2_vbseff),2))-0.5000000000*V(f_pmtrans2_g_k1))   ;
 V(f_pmtrans2_vdseff_cv) <+
0.5*V(f_pmtrans2_vdsat_cv)+0.5*V(f_pmtrans2_vds)+0.10e-1-0.5*mysqrt(pow(V(f_pmtrans2_vdsat_cv)-1.0*V(f_pmtrans2_vds)-0.2e-1,2)+0.8e-1*V(f_pmtrans2_vdsat_cv))   ;
 V(f_pmtrans2_faktor_t1) <+
12.0*V(f_pmtrans2_vgsteff)-6.0*V(f_pmtrans2_abulk_cv)*V(f_pmtrans2_vdseff_cv)+0.12e-18   ;
 V(f_pmtrans2_qs_ohne_o) <+
-0.1151044334e-2*ota_mbsim3v3_pmtrans2_w*V(f_pmtrans2_leff_cv)*(V(f_pmtrans2_vgsteff)-0.5*V(f_pmtrans2_vdseff_cv)+V(f_pmtrans2_abulk_cv)*pow(V(f_pmtrans2_vdseff_cv),2)/V(f_pmtrans2_faktor_t1))-0.1151044334e-2*ota_mbsim3v3_pmtrans2_w*V(f_pmtrans2_leff_cv)*(1.0-1.0*V(f_pmtrans2_abulk_cv))*(0.5*V(f_pmtrans2_vdseff_cv)-1.0*V(f_pmtrans2_abulk_cv)*pow(V(f_pmtrans2_vdseff_cv),2)/V(f_pmtrans2_faktor_t1))   ;
 V(f_pmtrans2_g_qg) <+
0.2302088667e-2*ota_mbsim3v3_pmtrans2_w*V(f_pmtrans2_leff_cv)*(V(f_pmtrans2_vgsteff)-0.5*V(f_pmtrans2_vdseff_cv)+V(f_pmtrans2_abulk_cv)*pow(V(f_pmtrans2_vdseff_cv),2)/V(f_pmtrans2_faktor_t1))+V(f_pmtrans2_qac0)+V(f_pmtrans2_qsub0)   ;
 V(f_pmtrans2_qg) <+
V(f_pmtrans2_g_qg)+V(f_pmtrans2_qoverlap_s)+V(f_pmtrans2_qoverlap_d)   ;
 V(f_pmtrans2_g_qb) <+
0.2302088667e-2*ota_mbsim3v3_pmtrans2_w*V(f_pmtrans2_leff_cv)*(1.0-1.0*V(f_pmtrans2_abulk_cv))*(0.5*V(f_pmtrans2_vdseff_cv)-1.0*V(f_pmtrans2_abulk_cv)*pow(V(f_pmtrans2_vdseff_cv),2)/V(f_pmtrans2_faktor_t1))-1.0*V(f_pmtrans2_qac0)-1.0*V(f_pmtrans2_qsub0)   ;
 V(f_pmtrans2_qb) <+
V(f_pmtrans2_g_qb)   ;
 V(f_pmtrans2_g_qd) <+
-1.0*V(f_pmtrans2_g_qg)-1.0*V(f_pmtrans2_qs_ohne_o)-1.0*V(f_pmtrans2_g_qb)   ;
 V(f_pmtrans2_qd) <+
(1.0-1.0*V(f_pmtrans2_dir))*(V(f_pmtrans2_g_qd)-1.0*V(f_pmtrans2_qoverlap_d))+V(f_pmtrans2_dir)*(V(f_pmtrans2_qs_ohne_o)-1.0*V(f_pmtrans2_qoverlap_d))   ;
 V(f_pmtrans2_qs) <+
(1.0-1.0*V(f_pmtrans2_dir))*(V(f_pmtrans2_qs_ohne_o)-1.0*V(f_pmtrans2_qoverlap_s))+V(f_pmtrans2_dir)*(V(f_pmtrans2_g_qd)-1.0*V(f_pmtrans2_qoverlap_s))   ;
 V(f_nmtrans1_g_t) <+
_a50*$temperature-273.15+300.15-27.0*_a50   ;
 V(f_nmtrans1_g_ni) <+
0.2788434715e13*pow(V(f_nmtrans1_g_t),1.5)*exp(21.5565981-5802.261235*(1.16-0.702e-3*pow(V(f_nmtrans1_g_t),2)/(V(f_nmtrans1_g_t)+1108.0))/V(f_nmtrans1_g_t))   ;
 V(f_nmtrans1_g_k2) <+
0.4188640132*(1.777177754-0.1312808442e-1*mysqrt(V(f_nmtrans1_g_t)*ln(0.17e24/V(f_nmtrans1_g_ni))))/(0.2625616884e-1*mysqrt(V(f_nmtrans1_g_t)*ln(0.17e24/V(f_nmtrans1_g_ni))*(0.1723466006e-3*V(f_nmtrans1_g_t)*ln(0.17e24/V(f_nmtrans1_g_ni))+5.0))-0.3446932012e-3*V(f_nmtrans1_g_t)*ln(0.17e24/V(f_nmtrans1_g_ni))-5.0)   ;
 V(f_nmtrans1_g_k1) <+
0.6130457498-2.0*V(f_nmtrans1_g_k2)*mysqrt(0.1723466006e-3*V(f_nmtrans1_g_t)*ln(0.17e24/V(f_nmtrans1_g_ni))+5.0)   ;
 V(f_nmtrans1_vgsi) <+
V(nbias)-1.0*V(gnd)   ;
 V(f_nmtrans1_vdsi) <+
V(u_int1)-1.0*V(gnd)   ;
 V(f_nmtrans1_vbsi) <+
0.0   ;
 V(f_nmtrans1_dir) <+
_a51-1.0*_a51*_a52*(V(f_nmtrans1_vdsi) >= 0 ?  1.0 : 0.0 )   ;
 V(f_nmtrans1_vgs) <+
(1.0-1.0*V(f_nmtrans1_dir))*V(f_nmtrans1_vgsi)+V(f_nmtrans1_dir)*(V(f_nmtrans1_vgsi)-1.0*V(f_nmtrans1_vdsi))   ;
 V(f_nmtrans1_vds) <+
(1.0-2.0*V(f_nmtrans1_dir))*V(f_nmtrans1_vdsi)   ;
 V(f_nmtrans1_vbs) <+
(1.0-1.0*V(f_nmtrans1_dir))*V(f_nmtrans1_vbsi)+V(f_nmtrans1_dir)*(V(f_nmtrans1_vbsi)-1.0*V(f_nmtrans1_vdsi))   ;
 V(f_nmtrans1_g_y) <+
0.1551119405e-3*V(f_nmtrans1_g_t)*ln(0.17e24/V(f_nmtrans1_g_ni))-0.9*pow(V(f_nmtrans1_g_k1),2)/(4.0*pow(V(f_nmtrans1_g_k2),2)+0.1e-24)   ;
 V(f_nmtrans1_vbc) <+
-8.99925+0.25*V(f_nmtrans1_g_y)+0.25*mysqrt(pow(-29.999-1.0*V(f_nmtrans1_g_y),2)+0.120)-0.5*mysqrt(pow(11.9985-0.5*V(f_nmtrans1_g_y)-0.5*mysqrt(pow(-29.999-1.0*V(f_nmtrans1_g_y),2)+0.120),2)+0.12e-1)   ;
 V(f_nmtrans1_vbseff) <+
_a55*V(f_nmtrans1_vbc)+0.5*_a56*_a55*(V(f_nmtrans1_vbs)-1.0*V(f_nmtrans1_vbc)-0.1e-2+mysqrt(pow(V(f_nmtrans1_vbs)-1.0*V(f_nmtrans1_vbc)-0.1e-2,2)-0.4e-2*V(f_nmtrans1_vbc)))+(1.0-1.0*_a55)*_a56*V(f_nmtrans1_vbs)   ;
 V(f_nmtrans1_sqrtphis) <+
0.1723466006e-3*V(f_nmtrans1_g_t)*ln(0.17e24/V(f_nmtrans1_g_ni))*mysqrt(0.1723466006e-3*V(f_nmtrans1_g_t)*ln(0.17e24/V(f_nmtrans1_g_ni))-1.0*_a53*(0.5*V(f_nmtrans1_vbseff)-0.5*mysqrt(pow(V(f_nmtrans1_vbseff),2))))/(0.1723466006e-3*V(f_nmtrans1_g_t)*ln(0.17e24/V(f_nmtrans1_g_ni))+0.5*_a54*(0.5*V(f_nmtrans1_vbseff)+0.5*mysqrt(pow(V(f_nmtrans1_vbseff),2))))   ;
 V(f_nmtrans1_leff) <+
ota_mbsim3v3_nmtrans1_l   ;
 V(f_nmtrans1_weff_strich) <+
ota_mbsim3v3_nmtrans1_w   ;
 V(f_nmtrans1_leff_cv) <+
ota_mbsim3v3_nmtrans1_l   ;
 V(f_nmtrans1_lt1) <+
0.6264792526e-7*mysqrt(V(f_nmtrans1_sqrtphis))*((-0.32e-1*V(f_nmtrans1_vbseff)+0.5 >= 0 ?  1.0 : 0.0 )*(1.0-0.32e-1*V(f_nmtrans1_vbseff))+1.0*(1.0-1.0*(-0.32e-1*V(f_nmtrans1_vbseff)+0.5 >= 0 ?  1.0 : 0.0 ))*(1.0-0.960e-1*V(f_nmtrans1_vbseff))/(3.0-0.2560*V(f_nmtrans1_vbseff)))   ;
 V(f_nmtrans1_theta0vb0) <+
exp(-69656657.50*V(f_nmtrans1_leff)*pow(V(f_nmtrans1_g_t)*ln(0.17e24/V(f_nmtrans1_g_ni)),-0.2500000000))+2.0*pow(exp(-69656657.50*V(f_nmtrans1_leff)*pow(V(f_nmtrans1_g_t)*ln(0.17e24/V(f_nmtrans1_g_ni)),-0.2500000000)),2)   ;
 V(f_nmtrans1_v0) <+
0.8617330030e-4*V(f_nmtrans1_g_t)*ln(0.17e50*pow(V(f_nmtrans1_g_ni),-2))-0.1723466006e-3*V(f_nmtrans1_g_t)*ln(0.17e24/V(f_nmtrans1_g_ni))   ;
 V(f_nmtrans1_delt_vth) <+
2.2*V(f_nmtrans1_v0)*exp(-0.265*V(f_nmtrans1_leff)/V(f_nmtrans1_lt1))*(1.0+2.0*exp(-0.265*V(f_nmtrans1_leff)/V(f_nmtrans1_lt1)))   ;
 V(f_nmtrans1_vth_t22) <+
0.0   ;
 V(f_nmtrans1_vth_t1_t1) <+
0.1312808442e-1*_a68*V(f_nmtrans1_g_k1)*(mysqrt(1.0+0.174e-6/V(f_nmtrans1_leff))-1.0)*mysqrt(V(f_nmtrans1_g_t)*ln(0.17e24/V(f_nmtrans1_g_ni)))+_a49*(-0.11+0.22e-1*V(f_nmtrans1_vbseff))*(0.3331667500e-2*V(f_nmtrans1_g_t)-1.0)   ;
 V(f_nmtrans1_vth) <+
ota_mbsim3v3_n_mos_vth0+_a70*(_a58*(-0.1312808442e-1*V(f_nmtrans1_g_k1)*mysqrt(V(f_nmtrans1_g_t)*ln(0.17e24/V(f_nmtrans1_g_ni)))+1.000000000*V(f_nmtrans1_g_k1)*V(f_nmtrans1_sqrtphis)-1.000000000*V(f_nmtrans1_g_k2)*V(f_nmtrans1_vbseff))-1.0*_a59*V(f_nmtrans1_delt_vth)-1.0*_a59*V(f_nmtrans1_vth_t22)+0.2068159207e-9*V(f_nmtrans1_g_t)*ln(0.17e24/V(f_nmtrans1_g_ni))/(V(f_nmtrans1_weff_strich)+0.25e-5)+V(f_nmtrans1_vth_t1_t1)-1.0*_a65*V(f_nmtrans1_vds)*V(f_nmtrans1_theta0vb0)*(0.8e-1-0.7e-1*V(f_nmtrans1_vbseff)))   ;
 V(f_nmtrans1_scvt) <+
exp(-4229988.446*V(f_nmtrans1_leff)*pow(V(f_nmtrans1_sqrtphis),-0.5000000000)/(1.0-0.32e-1*_a59*V(f_nmtrans1_vbseff)))+2.0*exp(-8459976.892*V(f_nmtrans1_leff)*pow(V(f_nmtrans1_sqrtphis),-0.5000000000)/(1.0-0.32e-1*_a59*V(f_nmtrans1_vbseff)))   ;
 V(f_nmtrans1_nvgs) <+
0.5159548816/V(f_nmtrans1_sqrtphis)+0.1042531521*_a59*V(f_nmtrans1_scvt)   ;
 V(f_nmtrans1_vgsteff) <+
(0.1723466006e-3*_a60*_a61*(V(f_nmtrans1_nvgs)+1.0)*V(f_nmtrans1_g_t)*ln(1.0+exp(5802.261235*(V(f_nmtrans1_vgs)-1.0*V(f_nmtrans1_vth))/(V(f_nmtrans1_nvgs)+1.0)/V(f_nmtrans1_g_t)))+(1.0-1.0*_a60)*_a61*(V(f_nmtrans1_vgs)-1.0*V(f_nmtrans1_vth)))/(1.0+0.5088849782e-1*_a60*_a61*(V(f_nmtrans1_nvgs)+1.0)*mysqrt(V(f_nmtrans1_g_t)*ln(0.17e24/V(f_nmtrans1_g_ni)))*exp(5802.261235*(-1.0*V(f_nmtrans1_vgs)+V(f_nmtrans1_vth)-0.16)/(V(f_nmtrans1_nvgs)+1.0)/V(f_nmtrans1_g_t)))   ;
 V(f_nmtrans1_weff) <+
ota_mbsim3v3_nmtrans1_w   ;
 V(f_nmtrans1_ueff) <+
0.670e-1/(1.0+_a71*(66666666.67*(0.225e-8-0.465e-10*_a58*V(f_nmtrans1_vbseff))*(V(f_nmtrans1_vgsteff)+2.0*V(f_nmtrans1_vth))+0.2608888889e-2*pow(V(f_nmtrans1_vgsteff)+2.0*V(f_nmtrans1_vth),2)))   ;
 V(f_nmtrans1_abulkp) <+
(1.0+0.5000000000*V(f_nmtrans1_g_k1)/V(f_nmtrans1_sqrtphis)*V(f_nmtrans1_leff)/(V(f_nmtrans1_leff)+0.2287578680e-6*mysqrt(V(f_nmtrans1_sqrtphis))))/(1.0-0.47e-1*V(f_nmtrans1_vbseff))   ;
 V(f_nmtrans1_abulk) <+
_a62*(0.5*V(f_nmtrans1_abulkp)+0.245e-1+0.5*mysqrt(pow(V(f_nmtrans1_abulkp)-0.51e-1,2)+0.4e-2))+(1.0-1.0*_a62)*V(f_nmtrans1_abulkp)   ;
 V(f_nmtrans1_temp3) <+
0.160e6*(V(f_nmtrans1_vgsteff)+0.1723466006e-3*_a67*V(f_nmtrans1_g_t))/V(f_nmtrans1_ueff)*V(f_nmtrans1_leff)   ;
 V(f_nmtrans1_temp2) <+
-1.000000000*V(f_nmtrans1_vgsteff)-0.1723466006e-3*_a67*V(f_nmtrans1_g_t)-0.160e6*V(f_nmtrans1_abulk)/V(f_nmtrans1_ueff)*V(f_nmtrans1_leff)   ;
 V(f_nmtrans1_vdsat) <+
0.160e6/V(f_nmtrans1_ueff)*V(f_nmtrans1_leff)*(V(f_nmtrans1_vgsteff)+0.1723466006e-3*_a67*V(f_nmtrans1_g_t))/(0.160e6*V(f_nmtrans1_abulk)/V(f_nmtrans1_ueff)*V(f_nmtrans1_leff)+_a69*(V(f_nmtrans1_vgsteff)+0.1723466006e-3*_a67*V(f_nmtrans1_g_t)))   ;
 V(f_nmtrans1_vdseff) <+
_a64*V(f_nmtrans1_vdsat)-0.5*_a63*_a64*(V(f_nmtrans1_vdsat)-1.0*V(f_nmtrans1_vds)-0.1e-1+mysqrt(pow(V(f_nmtrans1_vdsat)-1.0*V(f_nmtrans1_vds)-0.1e-1,2)+0.4e-1*V(f_nmtrans1_vdsat)))+(1.0-1.0*_a64)*_a63*V(f_nmtrans1_vds)   ;
 V(f_nmtrans1_vasat_t9) <+
0.0   ;
 V(f_nmtrans1_vasat_t0) <+
0.160e6/V(f_nmtrans1_ueff)*V(f_nmtrans1_leff)+V(f_nmtrans1_vdsat)+2.0*V(f_nmtrans1_vasat_t9)*(1.0-0.5*V(f_nmtrans1_abulk)*V(f_nmtrans1_vdsat)/(V(f_nmtrans1_vgsteff)+0.17234174e-3*_a67*V(f_nmtrans1_g_t)))   ;
 V(f_nmtrans1_vasat) <+
1.000000000*V(f_nmtrans1_vasat_t0)   ;
 V(f_nmtrans1_e_vascbe) <+
0.10e-4*_a64/V(f_nmtrans1_leff)*exp(-34.83515634/(V(f_nmtrans1_vds)-1.0*V(f_nmtrans1_vdseff)+0.1e-9))   ;
 V(f_nmtrans1_vadiblc) <+
(V(f_nmtrans1_vgsteff)+0.1723466006e-3*_a67*V(f_nmtrans1_g_t))/(0.39*exp(-39007728.23*V(f_nmtrans1_leff)*pow(V(f_nmtrans1_g_t)*ln(0.17e24/V(f_nmtrans1_g_ni)),-0.2500000000))+0.78*exp(-78015456.46*V(f_nmtrans1_leff)*pow(V(f_nmtrans1_g_t)*ln(0.17e24/V(f_nmtrans1_g_ni)),-0.2500000000))+0.86e-2)*(1.0-1.0*V(f_nmtrans1_abulk)*V(f_nmtrans1_vdsat)/(V(f_nmtrans1_abulk)*V(f_nmtrans1_vdsat)+V(f_nmtrans1_vgsteff)+0.1723466006e-3*_a67*V(f_nmtrans1_g_t)))   ;
 V(f_nmtrans1_vaclm) <+
9362778.307*_a64*V(f_nmtrans1_leff)*(V(f_nmtrans1_abulk)+0.6250000000e-5*_a69*V(f_nmtrans1_vgsteff)*V(f_nmtrans1_ueff)/V(f_nmtrans1_leff))/V(f_nmtrans1_abulk)*(V(f_nmtrans1_vds)-1.0*V(f_nmtrans1_vdseff)+0.1e-9)+0.1e-9-0.1e-9*_a64   ;
 V(f_nmtrans1_vafaktor) <+
_a65*_a66/(1.0/V(f_nmtrans1_vaclm)+1.0/V(f_nmtrans1_vadiblc))+(1.0-1.0*_a65)*_a66*V(f_nmtrans1_vaclm)+_a65*(1.0-1.0*_a66)*V(f_nmtrans1_vadiblc)   ;
 V(f_nmtrans1_va) <+
V(f_nmtrans1_vasat)+V(f_nmtrans1_vafaktor)   ;
 V(f_nmtrans1_idso) <+
0.2302088667e-2*V(f_nmtrans1_weff)*V(f_nmtrans1_ueff)*V(f_nmtrans1_vgsteff)*(1.0-1.0*V(f_nmtrans1_abulk)*V(f_nmtrans1_vdseff)/(2.0*V(f_nmtrans1_vgsteff)+0.3446932012e-3*_a67*V(f_nmtrans1_g_t)))*V(f_nmtrans1_vdseff)/V(f_nmtrans1_leff)/(1.0+0.6250000000e-5*_a69*V(f_nmtrans1_vdseff)*V(f_nmtrans1_ueff)/V(f_nmtrans1_leff))   ;
 V(f_nmtrans1_idsx) <+
V(f_nmtrans1_idso)*(1.0+_a64*_a57*(V(f_nmtrans1_vds)-1.0*V(f_nmtrans1_vdseff))*V(f_nmtrans1_e_vascbe))*(1.0+_a64*(_a65+_a66-0.5 >= 0 ?  1.0 : 0.0 )*(V(f_nmtrans1_vds)-1.0*V(f_nmtrans1_vdseff))/V(f_nmtrans1_va))   ;
 V(f_nmtrans1_ids) <+
(1.0-2.0*V(f_nmtrans1_dir))*V(f_nmtrans1_idsx)   ;
 V(f_nmtrans1_cgdo_strich) <+
0.2801776464e-9*ota_mbsim3v3_nmtrans1_w   ;
 V(f_nmtrans1_cgso_strich) <+
0.2801776464e-9*ota_mbsim3v3_nmtrans1_w   ;
 V(f_nmtrans1_echte_vgd) <+
V(f_nmtrans1_vgsi)-1.0*V(f_nmtrans1_vdsi)   ;
 V(f_nmtrans1_echte_vgs) <+
V(f_nmtrans1_vgsi)   ;
 V(f_nmtrans1_echte_vgb) <+
V(f_nmtrans1_vgsi)-1.0*V(f_nmtrans1_vbsi)   ;
 V(f_nmtrans1_qgdo_T0) <+
V(f_nmtrans1_echte_vgd)+0.2e-1   ;
 V(f_nmtrans1_qgdo_T1) <+
mysqrt(pow(V(f_nmtrans1_qgdo_T0),2)+0.8e-1)   ;
 V(f_nmtrans1_qgdo_T2) <+
0.5*V(f_nmtrans1_qgdo_T0)-0.5*V(f_nmtrans1_qgdo_T1)   ;
 V(f_nmtrans1_qgdo_T3) <+
0.0   ;
 V(f_nmtrans1_qgdo_T4) <+
mysqrt(1.0-6.666666668*V(f_nmtrans1_qgdo_T2))   ;
 V(f_nmtrans1_qgso_T0) <+
V(f_nmtrans1_echte_vgs)+0.2e-1   ;
 V(f_nmtrans1_qgso_T1) <+
mysqrt(pow(V(f_nmtrans1_qgso_T0),2)+0.8e-1)   ;
 V(f_nmtrans1_qgso_T2) <+
0.5*V(f_nmtrans1_qgso_T0)-0.5*V(f_nmtrans1_qgso_T1)   ;
 V(f_nmtrans1_qgso_T3) <+
0.0   ;
 V(f_nmtrans1_qgso_T4) <+
mysqrt(1.0-6.666666668*V(f_nmtrans1_qgso_T2))   ;
 V(f_nmtrans1_qoverlap_d) <+
(V(f_nmtrans1_cgdo_strich)+V(f_nmtrans1_qgdo_T3))*V(f_nmtrans1_echte_vgd)-1.0*V(f_nmtrans1_qgdo_T3)*(V(f_nmtrans1_qgdo_T2)+0.30*V(f_nmtrans1_qgdo_T4)-0.300)   ;
 V(f_nmtrans1_qoverlap_s) <+
(V(f_nmtrans1_cgso_strich)+V(f_nmtrans1_qgso_T3))*V(f_nmtrans1_echte_vgs)-1.0*V(f_nmtrans1_qgso_T3)*(V(f_nmtrans1_qgso_T2)+0.30*V(f_nmtrans1_qgso_T4)-0.300)   ;
 V(f_nmtrans1_v3) <+
ota_mbsim3v3_n_mos_vth0-0.1723466006e-3*V(f_nmtrans1_g_t)*ln(0.17e24/V(f_nmtrans1_g_ni))-0.1312808442e-1*V(f_nmtrans1_g_k1)*mysqrt(V(f_nmtrans1_g_t)*ln(0.17e24/V(f_nmtrans1_g_ni)))-1.0*V(f_nmtrans1_vgs)+V(f_nmtrans1_vbseff)-0.2e-1   ;
 V(f_nmtrans1_vfbeff) <+
ota_mbsim3v3_n_mos_vth0-0.1723466006e-3*V(f_nmtrans1_g_t)*ln(0.17e24/V(f_nmtrans1_g_ni))-0.1312808442e-1*V(f_nmtrans1_g_k1)*mysqrt(V(f_nmtrans1_g_t)*ln(0.17e24/V(f_nmtrans1_g_ni)))-0.5*V(f_nmtrans1_v3)-0.5*mysqrt(pow(V(f_nmtrans1_v3),2)+0.8e-1*mysqrt(pow(ota_mbsim3v3_n_mos_vth0-0.1723466006e-3*V(f_nmtrans1_g_t)*ln(0.17e24/V(f_nmtrans1_g_ni))-0.1312808442e-1*V(f_nmtrans1_g_k1)*mysqrt(V(f_nmtrans1_g_t)*ln(0.17e24/V(f_nmtrans1_g_ni))),2)))   ;
 V(f_nmtrans1_qac0) <+
0.2302088667e-2*ota_mbsim3v3_nmtrans1_w*V(f_nmtrans1_leff_cv)*(V(f_nmtrans1_vfbeff)-1.0*ota_mbsim3v3_n_mos_vth0+0.1723466006e-3*V(f_nmtrans1_g_t)*ln(0.17e24/V(f_nmtrans1_g_ni))+0.1312808442e-1*V(f_nmtrans1_g_k1)*mysqrt(V(f_nmtrans1_g_t)*ln(0.17e24/V(f_nmtrans1_g_ni))))   ;
 V(f_nmtrans1_abulk_cv) <+
(0.5*(1.0+0.5000000000*V(f_nmtrans1_g_k1)/V(f_nmtrans1_sqrtphis)*V(f_nmtrans1_leff)/(V(f_nmtrans1_leff)+0.2287578680e-6*mysqrt(V(f_nmtrans1_sqrtphis))))/(1.0-0.47e-1*V(f_nmtrans1_vbseff))+0.245e-1+0.5*mysqrt(pow((1.0+0.5000000000*V(f_nmtrans1_g_k1)/V(f_nmtrans1_sqrtphis)*V(f_nmtrans1_leff)/(V(f_nmtrans1_leff)+0.2287578680e-6*mysqrt(V(f_nmtrans1_sqrtphis))))/(1.0-0.47e-1*V(f_nmtrans1_vbseff))-0.51e-1,2)+0.4e-2))*(1.0+0.6309573445e-4*pow(1.0/V(f_nmtrans1_leff),0.6))   ;
 V(f_nmtrans1_vdsat_cv) <+
V(f_nmtrans1_vgsteff)/V(f_nmtrans1_abulk_cv)   ;
 V(f_nmtrans1_qsub0) <+
0.2302088667e-2*ota_mbsim3v3_nmtrans1_w*V(f_nmtrans1_leff_cv)*V(f_nmtrans1_g_k1)*(pow(pow(0.2500000000*pow(V(f_nmtrans1_g_k1),2)+0.5*V(f_nmtrans1_vgs)-0.5*V(f_nmtrans1_vfbeff)-0.5*V(f_nmtrans1_vgsteff)-0.5*V(f_nmtrans1_vbseff)+0.5*mysqrt(pow(V(f_nmtrans1_vgs)-1.0*V(f_nmtrans1_vfbeff)-1.0*V(f_nmtrans1_vgsteff)-1.0*V(f_nmtrans1_vbseff),2)),2),0.2500000000)+0.5*V(f_nmtrans1_vgs)-0.5*V(f_nmtrans1_vfbeff)-0.5*V(f_nmtrans1_vgsteff)-0.5*V(f_nmtrans1_vbseff)-0.5*mysqrt(pow(V(f_nmtrans1_vgs)-1.0*V(f_nmtrans1_vfbeff)-1.0*V(f_nmtrans1_vgsteff)-1.0*V(f_nmtrans1_vbseff),2))-0.5000000000*V(f_nmtrans1_g_k1))   ;
 V(f_nmtrans1_vdseff_cv) <+
0.5*V(f_nmtrans1_vdsat_cv)+0.5*V(f_nmtrans1_vds)+0.10e-1-0.5*mysqrt(pow(V(f_nmtrans1_vdsat_cv)-1.0*V(f_nmtrans1_vds)-0.2e-1,2)+0.8e-1*V(f_nmtrans1_vdsat_cv))   ;
 V(f_nmtrans1_faktor_t1) <+
12.0*V(f_nmtrans1_vgsteff)-6.0*V(f_nmtrans1_abulk_cv)*V(f_nmtrans1_vdseff_cv)+0.12e-18   ;
 V(f_nmtrans1_qs_ohne_o) <+
-0.1151044334e-2*ota_mbsim3v3_nmtrans1_w*V(f_nmtrans1_leff_cv)*(V(f_nmtrans1_vgsteff)-0.5*V(f_nmtrans1_vdseff_cv)+V(f_nmtrans1_abulk_cv)*pow(V(f_nmtrans1_vdseff_cv),2)/V(f_nmtrans1_faktor_t1))-0.1151044334e-2*ota_mbsim3v3_nmtrans1_w*V(f_nmtrans1_leff_cv)*(1.0-1.0*V(f_nmtrans1_abulk_cv))*(0.5*V(f_nmtrans1_vdseff_cv)-1.0*V(f_nmtrans1_abulk_cv)*pow(V(f_nmtrans1_vdseff_cv),2)/V(f_nmtrans1_faktor_t1))   ;
 V(f_nmtrans1_g_qg) <+
0.2302088667e-2*ota_mbsim3v3_nmtrans1_w*V(f_nmtrans1_leff_cv)*(V(f_nmtrans1_vgsteff)-0.5*V(f_nmtrans1_vdseff_cv)+V(f_nmtrans1_abulk_cv)*pow(V(f_nmtrans1_vdseff_cv),2)/V(f_nmtrans1_faktor_t1))+V(f_nmtrans1_qac0)+V(f_nmtrans1_qsub0)   ;
 V(f_nmtrans1_qg) <+
V(f_nmtrans1_g_qg)+V(f_nmtrans1_qoverlap_s)+V(f_nmtrans1_qoverlap_d)   ;
 V(f_nmtrans1_g_qb) <+
0.2302088667e-2*ota_mbsim3v3_nmtrans1_w*V(f_nmtrans1_leff_cv)*(1.0-1.0*V(f_nmtrans1_abulk_cv))*(0.5*V(f_nmtrans1_vdseff_cv)-1.0*V(f_nmtrans1_abulk_cv)*pow(V(f_nmtrans1_vdseff_cv),2)/V(f_nmtrans1_faktor_t1))-1.0*V(f_nmtrans1_qac0)-1.0*V(f_nmtrans1_qsub0)   ;
 V(f_nmtrans1_qb) <+
V(f_nmtrans1_g_qb)   ;
 V(f_nmtrans1_g_qd) <+
-1.0*V(f_nmtrans1_g_qg)-1.0*V(f_nmtrans1_qs_ohne_o)-1.0*V(f_nmtrans1_g_qb)   ;
 V(f_nmtrans1_qd) <+
(1.0-1.0*V(f_nmtrans1_dir))*(V(f_nmtrans1_g_qd)-1.0*V(f_nmtrans1_qoverlap_d))+V(f_nmtrans1_dir)*(V(f_nmtrans1_qs_ohne_o)-1.0*V(f_nmtrans1_qoverlap_d))   ;
 V(f_nmtrans1_qs) <+
(1.0-1.0*V(f_nmtrans1_dir))*(V(f_nmtrans1_qs_ohne_o)-1.0*V(f_nmtrans1_qoverlap_s))+V(f_nmtrans1_dir)*(V(f_nmtrans1_g_qd)-1.0*V(f_nmtrans1_qoverlap_s))   ;
 V(f_nmtrans2_g_t) <+
_a74*$temperature-273.15+300.15-27.0*_a74   ;
 V(f_nmtrans2_g_ni) <+
0.2788434715e13*pow(V(f_nmtrans2_g_t),1.5)*exp(21.5565981-5802.261235*(1.16-0.702e-3*pow(V(f_nmtrans2_g_t),2)/(V(f_nmtrans2_g_t)+1108.0))/V(f_nmtrans2_g_t))   ;
 V(f_nmtrans2_g_k2) <+
0.4188640132*(1.777177754-0.1312808442e-1*mysqrt(V(f_nmtrans2_g_t)*ln(0.17e24/V(f_nmtrans2_g_ni))))/(0.2625616884e-1*mysqrt(V(f_nmtrans2_g_t)*ln(0.17e24/V(f_nmtrans2_g_ni))*(0.1723466006e-3*V(f_nmtrans2_g_t)*ln(0.17e24/V(f_nmtrans2_g_ni))+5.0))-0.3446932012e-3*V(f_nmtrans2_g_t)*ln(0.17e24/V(f_nmtrans2_g_ni))-5.0)   ;
 V(f_nmtrans2_g_k1) <+
0.6130457498-2.0*V(f_nmtrans2_g_k2)*mysqrt(0.1723466006e-3*V(f_nmtrans2_g_t)*ln(0.17e24/V(f_nmtrans2_g_ni))+5.0)   ;
 V(f_nmtrans2_vgsi) <+
V(nbias)-1.0*V(gnd)   ;
 V(f_nmtrans2_vdsi) <+
V(out1)-1.0*V(gnd)   ;
 V(f_nmtrans2_vbsi) <+
0.0   ;
 V(f_nmtrans2_dir) <+
_a75-1.0*_a75*_a76*(V(f_nmtrans2_vdsi) >= 0 ?  1.0 : 0.0 )   ;
 V(f_nmtrans2_vgs) <+
(1.0-1.0*V(f_nmtrans2_dir))*V(f_nmtrans2_vgsi)+V(f_nmtrans2_dir)*(V(f_nmtrans2_vgsi)-1.0*V(f_nmtrans2_vdsi))   ;
 V(f_nmtrans2_vds) <+
(1.0-2.0*V(f_nmtrans2_dir))*V(f_nmtrans2_vdsi)   ;
 V(f_nmtrans2_vbs) <+
(1.0-1.0*V(f_nmtrans2_dir))*V(f_nmtrans2_vbsi)+V(f_nmtrans2_dir)*(V(f_nmtrans2_vbsi)-1.0*V(f_nmtrans2_vdsi))   ;
 V(f_nmtrans2_g_y) <+
0.1551119405e-3*V(f_nmtrans2_g_t)*ln(0.17e24/V(f_nmtrans2_g_ni))-0.9*pow(V(f_nmtrans2_g_k1),2)/(4.0*pow(V(f_nmtrans2_g_k2),2)+0.1e-24)   ;
 V(f_nmtrans2_vbc) <+
-8.99925+0.25*V(f_nmtrans2_g_y)+0.25*mysqrt(pow(-29.999-1.0*V(f_nmtrans2_g_y),2)+0.120)-0.5*mysqrt(pow(11.9985-0.5*V(f_nmtrans2_g_y)-0.5*mysqrt(pow(-29.999-1.0*V(f_nmtrans2_g_y),2)+0.120),2)+0.12e-1)   ;
 V(f_nmtrans2_vbseff) <+
_a79*V(f_nmtrans2_vbc)+0.5*_a80*_a79*(V(f_nmtrans2_vbs)-1.0*V(f_nmtrans2_vbc)-0.1e-2+mysqrt(pow(V(f_nmtrans2_vbs)-1.0*V(f_nmtrans2_vbc)-0.1e-2,2)-0.4e-2*V(f_nmtrans2_vbc)))+(1.0-1.0*_a79)*_a80*V(f_nmtrans2_vbs)   ;
 V(f_nmtrans2_sqrtphis) <+
0.1723466006e-3*V(f_nmtrans2_g_t)*ln(0.17e24/V(f_nmtrans2_g_ni))*mysqrt(0.1723466006e-3*V(f_nmtrans2_g_t)*ln(0.17e24/V(f_nmtrans2_g_ni))-1.0*_a77*(0.5*V(f_nmtrans2_vbseff)-0.5*mysqrt(pow(V(f_nmtrans2_vbseff),2))))/(0.1723466006e-3*V(f_nmtrans2_g_t)*ln(0.17e24/V(f_nmtrans2_g_ni))+0.5*_a78*(0.5*V(f_nmtrans2_vbseff)+0.5*mysqrt(pow(V(f_nmtrans2_vbseff),2))))   ;
 V(f_nmtrans2_leff) <+
ota_mbsim3v3_nmtrans2_l   ;
 V(f_nmtrans2_weff_strich) <+
ota_mbsim3v3_nmtrans2_w   ;
 V(f_nmtrans2_leff_cv) <+
ota_mbsim3v3_nmtrans2_l   ;
 V(f_nmtrans2_lt1) <+
0.6264792526e-7*mysqrt(V(f_nmtrans2_sqrtphis))*((-0.32e-1*V(f_nmtrans2_vbseff)+0.5 >= 0 ?  1.0 : 0.0 )*(1.0-0.32e-1*V(f_nmtrans2_vbseff))+1.0*(1.0-1.0*(-0.32e-1*V(f_nmtrans2_vbseff)+0.5 >= 0 ?  1.0 : 0.0 ))*(1.0-0.960e-1*V(f_nmtrans2_vbseff))/(3.0-0.2560*V(f_nmtrans2_vbseff)))   ;
 V(f_nmtrans2_theta0vb0) <+
exp(-69656657.50*V(f_nmtrans2_leff)*pow(V(f_nmtrans2_g_t)*ln(0.17e24/V(f_nmtrans2_g_ni)),-0.2500000000))+2.0*pow(exp(-69656657.50*V(f_nmtrans2_leff)*pow(V(f_nmtrans2_g_t)*ln(0.17e24/V(f_nmtrans2_g_ni)),-0.2500000000)),2)   ;
 V(f_nmtrans2_v0) <+
0.8617330030e-4*V(f_nmtrans2_g_t)*ln(0.17e50*pow(V(f_nmtrans2_g_ni),-2))-0.1723466006e-3*V(f_nmtrans2_g_t)*ln(0.17e24/V(f_nmtrans2_g_ni))   ;
 V(f_nmtrans2_delt_vth) <+
2.2*V(f_nmtrans2_v0)*exp(-0.265*V(f_nmtrans2_leff)/V(f_nmtrans2_lt1))*(1.0+2.0*exp(-0.265*V(f_nmtrans2_leff)/V(f_nmtrans2_lt1)))   ;
 V(f_nmtrans2_vth_t22) <+
0.0   ;
 V(f_nmtrans2_vth_t1_t1) <+
0.1312808442e-1*_a92*V(f_nmtrans2_g_k1)*(mysqrt(1.0+0.174e-6/V(f_nmtrans2_leff))-1.0)*mysqrt(V(f_nmtrans2_g_t)*ln(0.17e24/V(f_nmtrans2_g_ni)))+_a73*(-0.11+0.22e-1*V(f_nmtrans2_vbseff))*(0.3331667500e-2*V(f_nmtrans2_g_t)-1.0)   ;
 V(f_nmtrans2_vth) <+
ota_mbsim3v3_n_mos_vth0+_a94*(_a82*(-0.1312808442e-1*V(f_nmtrans2_g_k1)*mysqrt(V(f_nmtrans2_g_t)*ln(0.17e24/V(f_nmtrans2_g_ni)))+1.000000000*V(f_nmtrans2_g_k1)*V(f_nmtrans2_sqrtphis)-1.000000000*V(f_nmtrans2_g_k2)*V(f_nmtrans2_vbseff))-1.0*_a83*V(f_nmtrans2_delt_vth)-1.0*_a83*V(f_nmtrans2_vth_t22)+0.2068159207e-9*V(f_nmtrans2_g_t)*ln(0.17e24/V(f_nmtrans2_g_ni))/(V(f_nmtrans2_weff_strich)+0.25e-5)+V(f_nmtrans2_vth_t1_t1)-1.0*_a89*V(f_nmtrans2_vds)*V(f_nmtrans2_theta0vb0)*(0.8e-1-0.7e-1*V(f_nmtrans2_vbseff)))   ;
 V(f_nmtrans2_scvt) <+
exp(-4229988.446*V(f_nmtrans2_leff)*pow(V(f_nmtrans2_sqrtphis),-0.5000000000)/(1.0-0.32e-1*_a83*V(f_nmtrans2_vbseff)))+2.0*exp(-8459976.892*V(f_nmtrans2_leff)*pow(V(f_nmtrans2_sqrtphis),-0.5000000000)/(1.0-0.32e-1*_a83*V(f_nmtrans2_vbseff)))   ;
 V(f_nmtrans2_nvgs) <+
0.5159548816/V(f_nmtrans2_sqrtphis)+0.1042531521*_a83*V(f_nmtrans2_scvt)   ;
 V(f_nmtrans2_vgsteff) <+
(0.1723466006e-3*_a84*_a85*(V(f_nmtrans2_nvgs)+1.0)*V(f_nmtrans2_g_t)*ln(1.0+exp(5802.261235*(V(f_nmtrans2_vgs)-1.0*V(f_nmtrans2_vth))/(V(f_nmtrans2_nvgs)+1.0)/V(f_nmtrans2_g_t)))+(1.0-1.0*_a84)*_a85*(V(f_nmtrans2_vgs)-1.0*V(f_nmtrans2_vth)))/(1.0+0.5088849782e-1*_a84*_a85*(V(f_nmtrans2_nvgs)+1.0)*mysqrt(V(f_nmtrans2_g_t)*ln(0.17e24/V(f_nmtrans2_g_ni)))*exp(5802.261235*(-1.0*V(f_nmtrans2_vgs)+V(f_nmtrans2_vth)-0.16)/(V(f_nmtrans2_nvgs)+1.0)/V(f_nmtrans2_g_t)))   ;
 V(f_nmtrans2_weff) <+
ota_mbsim3v3_nmtrans2_w   ;
 V(f_nmtrans2_ueff) <+
0.670e-1/(1.0+_a95*(66666666.67*(0.225e-8-0.465e-10*_a82*V(f_nmtrans2_vbseff))*(V(f_nmtrans2_vgsteff)+2.0*V(f_nmtrans2_vth))+0.2608888889e-2*pow(V(f_nmtrans2_vgsteff)+2.0*V(f_nmtrans2_vth),2)))   ;
 V(f_nmtrans2_abulkp) <+
(1.0+0.5000000000*V(f_nmtrans2_g_k1)/V(f_nmtrans2_sqrtphis)*V(f_nmtrans2_leff)/(V(f_nmtrans2_leff)+0.2287578680e-6*mysqrt(V(f_nmtrans2_sqrtphis))))/(1.0-0.47e-1*V(f_nmtrans2_vbseff))   ;
 V(f_nmtrans2_abulk) <+
_a86*(0.5*V(f_nmtrans2_abulkp)+0.245e-1+0.5*mysqrt(pow(V(f_nmtrans2_abulkp)-0.51e-1,2)+0.4e-2))+(1.0-1.0*_a86)*V(f_nmtrans2_abulkp)   ;
 V(f_nmtrans2_temp3) <+
0.160e6*(V(f_nmtrans2_vgsteff)+0.1723466006e-3*_a91*V(f_nmtrans2_g_t))/V(f_nmtrans2_ueff)*V(f_nmtrans2_leff)   ;
 V(f_nmtrans2_temp2) <+
-1.000000000*V(f_nmtrans2_vgsteff)-0.1723466006e-3*_a91*V(f_nmtrans2_g_t)-0.160e6*V(f_nmtrans2_abulk)/V(f_nmtrans2_ueff)*V(f_nmtrans2_leff)   ;
 V(f_nmtrans2_vdsat) <+
0.160e6/V(f_nmtrans2_ueff)*V(f_nmtrans2_leff)*(V(f_nmtrans2_vgsteff)+0.1723466006e-3*_a91*V(f_nmtrans2_g_t))/(0.160e6*V(f_nmtrans2_abulk)/V(f_nmtrans2_ueff)*V(f_nmtrans2_leff)+_a93*(V(f_nmtrans2_vgsteff)+0.1723466006e-3*_a91*V(f_nmtrans2_g_t)))   ;
 V(f_nmtrans2_vdseff) <+
_a88*V(f_nmtrans2_vdsat)-0.5*_a87*_a88*(V(f_nmtrans2_vdsat)-1.0*V(f_nmtrans2_vds)-0.1e-1+mysqrt(pow(V(f_nmtrans2_vdsat)-1.0*V(f_nmtrans2_vds)-0.1e-1,2)+0.4e-1*V(f_nmtrans2_vdsat)))+(1.0-1.0*_a88)*_a87*V(f_nmtrans2_vds)   ;
 V(f_nmtrans2_vasat_t9) <+
0.0   ;
 V(f_nmtrans2_vasat_t0) <+
0.160e6/V(f_nmtrans2_ueff)*V(f_nmtrans2_leff)+V(f_nmtrans2_vdsat)+2.0*V(f_nmtrans2_vasat_t9)*(1.0-0.5*V(f_nmtrans2_abulk)*V(f_nmtrans2_vdsat)/(V(f_nmtrans2_vgsteff)+0.17234174e-3*_a91*V(f_nmtrans2_g_t)))   ;
 V(f_nmtrans2_vasat) <+
1.000000000*V(f_nmtrans2_vasat_t0)   ;
 V(f_nmtrans2_e_vascbe) <+
0.10e-4*_a88/V(f_nmtrans2_leff)*exp(-34.83515634/(V(f_nmtrans2_vds)-1.0*V(f_nmtrans2_vdseff)+0.1e-9))   ;
 V(f_nmtrans2_vadiblc) <+
(V(f_nmtrans2_vgsteff)+0.1723466006e-3*_a91*V(f_nmtrans2_g_t))/(0.39*exp(-39007728.23*V(f_nmtrans2_leff)*pow(V(f_nmtrans2_g_t)*ln(0.17e24/V(f_nmtrans2_g_ni)),-0.2500000000))+0.78*exp(-78015456.46*V(f_nmtrans2_leff)*pow(V(f_nmtrans2_g_t)*ln(0.17e24/V(f_nmtrans2_g_ni)),-0.2500000000))+0.86e-2)*(1.0-1.0*V(f_nmtrans2_abulk)*V(f_nmtrans2_vdsat)/(V(f_nmtrans2_abulk)*V(f_nmtrans2_vdsat)+V(f_nmtrans2_vgsteff)+0.1723466006e-3*_a91*V(f_nmtrans2_g_t)))   ;
 V(f_nmtrans2_vaclm) <+
9362778.307*_a88*V(f_nmtrans2_leff)*(V(f_nmtrans2_abulk)+0.6250000000e-5*_a93*V(f_nmtrans2_vgsteff)*V(f_nmtrans2_ueff)/V(f_nmtrans2_leff))/V(f_nmtrans2_abulk)*(V(f_nmtrans2_vds)-1.0*V(f_nmtrans2_vdseff)+0.1e-9)+0.1e-9-0.1e-9*_a88   ;
 V(f_nmtrans2_vafaktor) <+
_a89*_a90/(1.0/V(f_nmtrans2_vaclm)+1.0/V(f_nmtrans2_vadiblc))+(1.0-1.0*_a89)*_a90*V(f_nmtrans2_vaclm)+_a89*(1.0-1.0*_a90)*V(f_nmtrans2_vadiblc)   ;
 V(f_nmtrans2_va) <+
V(f_nmtrans2_vasat)+V(f_nmtrans2_vafaktor)   ;
 V(f_nmtrans2_idso) <+
0.2302088667e-2*V(f_nmtrans2_weff)*V(f_nmtrans2_ueff)*V(f_nmtrans2_vgsteff)*(1.0-1.0*V(f_nmtrans2_abulk)*V(f_nmtrans2_vdseff)/(2.0*V(f_nmtrans2_vgsteff)+0.3446932012e-3*_a91*V(f_nmtrans2_g_t)))*V(f_nmtrans2_vdseff)/V(f_nmtrans2_leff)/(1.0+0.6250000000e-5*_a93*V(f_nmtrans2_vdseff)*V(f_nmtrans2_ueff)/V(f_nmtrans2_leff))   ;
 V(f_nmtrans2_idsx) <+
V(f_nmtrans2_idso)*(1.0+_a88*_a81*(V(f_nmtrans2_vds)-1.0*V(f_nmtrans2_vdseff))*V(f_nmtrans2_e_vascbe))*(1.0+_a88*(_a89+_a90-0.5 >= 0 ?  1.0 : 0.0 )*(V(f_nmtrans2_vds)-1.0*V(f_nmtrans2_vdseff))/V(f_nmtrans2_va))   ;
 V(f_nmtrans2_ids) <+
(1.0-2.0*V(f_nmtrans2_dir))*V(f_nmtrans2_idsx)   ;
 V(f_nmtrans2_cgdo_strich) <+
0.2801776464e-9*ota_mbsim3v3_nmtrans2_w   ;
 V(f_nmtrans2_cgso_strich) <+
0.2801776464e-9*ota_mbsim3v3_nmtrans2_w   ;
 V(f_nmtrans2_echte_vgd) <+
V(f_nmtrans2_vgsi)-1.0*V(f_nmtrans2_vdsi)   ;
 V(f_nmtrans2_echte_vgs) <+
V(f_nmtrans2_vgsi)   ;
 V(f_nmtrans2_echte_vgb) <+
V(f_nmtrans2_vgsi)-1.0*V(f_nmtrans2_vbsi)   ;
 V(f_nmtrans2_qgdo_T0) <+
V(f_nmtrans2_echte_vgd)+0.2e-1   ;
 V(f_nmtrans2_qgdo_T1) <+
mysqrt(pow(V(f_nmtrans2_qgdo_T0),2)+0.8e-1)   ;
 V(f_nmtrans2_qgdo_T2) <+
0.5*V(f_nmtrans2_qgdo_T0)-0.5*V(f_nmtrans2_qgdo_T1)   ;
 V(f_nmtrans2_qgdo_T3) <+
0.0   ;
 V(f_nmtrans2_qgdo_T4) <+
mysqrt(1.0-6.666666668*V(f_nmtrans2_qgdo_T2))   ;
 V(f_nmtrans2_qgso_T0) <+
V(f_nmtrans2_echte_vgs)+0.2e-1   ;
 V(f_nmtrans2_qgso_T1) <+
mysqrt(pow(V(f_nmtrans2_qgso_T0),2)+0.8e-1)   ;
 V(f_nmtrans2_qgso_T2) <+
0.5*V(f_nmtrans2_qgso_T0)-0.5*V(f_nmtrans2_qgso_T1)   ;
 V(f_nmtrans2_qgso_T3) <+
0.0   ;
 V(f_nmtrans2_qgso_T4) <+
mysqrt(1.0-6.666666668*V(f_nmtrans2_qgso_T2))   ;
 V(f_nmtrans2_qoverlap_d) <+
(V(f_nmtrans2_cgdo_strich)+V(f_nmtrans2_qgdo_T3))*V(f_nmtrans2_echte_vgd)-1.0*V(f_nmtrans2_qgdo_T3)*(V(f_nmtrans2_qgdo_T2)+0.30*V(f_nmtrans2_qgdo_T4)-0.300)   ;
 V(f_nmtrans2_qoverlap_s) <+
(V(f_nmtrans2_cgso_strich)+V(f_nmtrans2_qgso_T3))*V(f_nmtrans2_echte_vgs)-1.0*V(f_nmtrans2_qgso_T3)*(V(f_nmtrans2_qgso_T2)+0.30*V(f_nmtrans2_qgso_T4)-0.300)   ;
 V(f_nmtrans2_v3) <+
ota_mbsim3v3_n_mos_vth0-0.1723466006e-3*V(f_nmtrans2_g_t)*ln(0.17e24/V(f_nmtrans2_g_ni))-0.1312808442e-1*V(f_nmtrans2_g_k1)*mysqrt(V(f_nmtrans2_g_t)*ln(0.17e24/V(f_nmtrans2_g_ni)))-1.0*V(f_nmtrans2_vgs)+V(f_nmtrans2_vbseff)-0.2e-1   ;
 V(f_nmtrans2_vfbeff) <+
ota_mbsim3v3_n_mos_vth0-0.1723466006e-3*V(f_nmtrans2_g_t)*ln(0.17e24/V(f_nmtrans2_g_ni))-0.1312808442e-1*V(f_nmtrans2_g_k1)*mysqrt(V(f_nmtrans2_g_t)*ln(0.17e24/V(f_nmtrans2_g_ni)))-0.5*V(f_nmtrans2_v3)-0.5*mysqrt(pow(V(f_nmtrans2_v3),2)+0.8e-1*mysqrt(pow(ota_mbsim3v3_n_mos_vth0-0.1723466006e-3*V(f_nmtrans2_g_t)*ln(0.17e24/V(f_nmtrans2_g_ni))-0.1312808442e-1*V(f_nmtrans2_g_k1)*mysqrt(V(f_nmtrans2_g_t)*ln(0.17e24/V(f_nmtrans2_g_ni))),2)))   ;
 V(f_nmtrans2_qac0) <+
0.2302088667e-2*ota_mbsim3v3_nmtrans2_w*V(f_nmtrans2_leff_cv)*(V(f_nmtrans2_vfbeff)-1.0*ota_mbsim3v3_n_mos_vth0+0.1723466006e-3*V(f_nmtrans2_g_t)*ln(0.17e24/V(f_nmtrans2_g_ni))+0.1312808442e-1*V(f_nmtrans2_g_k1)*mysqrt(V(f_nmtrans2_g_t)*ln(0.17e24/V(f_nmtrans2_g_ni))))   ;
 V(f_nmtrans2_abulk_cv) <+
(0.5*(1.0+0.5000000000*V(f_nmtrans2_g_k1)/V(f_nmtrans2_sqrtphis)*V(f_nmtrans2_leff)/(V(f_nmtrans2_leff)+0.2287578680e-6*mysqrt(V(f_nmtrans2_sqrtphis))))/(1.0-0.47e-1*V(f_nmtrans2_vbseff))+0.245e-1+0.5*mysqrt(pow((1.0+0.5000000000*V(f_nmtrans2_g_k1)/V(f_nmtrans2_sqrtphis)*V(f_nmtrans2_leff)/(V(f_nmtrans2_leff)+0.2287578680e-6*mysqrt(V(f_nmtrans2_sqrtphis))))/(1.0-0.47e-1*V(f_nmtrans2_vbseff))-0.51e-1,2)+0.4e-2))*(1.0+0.6309573445e-4*pow(1.0/V(f_nmtrans2_leff),0.6))   ;
 V(f_nmtrans2_vdsat_cv) <+
V(f_nmtrans2_vgsteff)/V(f_nmtrans2_abulk_cv)   ;
 V(f_nmtrans2_qsub0) <+
0.2302088667e-2*ota_mbsim3v3_nmtrans2_w*V(f_nmtrans2_leff_cv)*V(f_nmtrans2_g_k1)*(pow(pow(0.2500000000*pow(V(f_nmtrans2_g_k1),2)+0.5*V(f_nmtrans2_vgs)-0.5*V(f_nmtrans2_vfbeff)-0.5*V(f_nmtrans2_vgsteff)-0.5*V(f_nmtrans2_vbseff)+0.5*mysqrt(pow(V(f_nmtrans2_vgs)-1.0*V(f_nmtrans2_vfbeff)-1.0*V(f_nmtrans2_vgsteff)-1.0*V(f_nmtrans2_vbseff),2)),2),0.2500000000)+0.5*V(f_nmtrans2_vgs)-0.5*V(f_nmtrans2_vfbeff)-0.5*V(f_nmtrans2_vgsteff)-0.5*V(f_nmtrans2_vbseff)-0.5*mysqrt(pow(V(f_nmtrans2_vgs)-1.0*V(f_nmtrans2_vfbeff)-1.0*V(f_nmtrans2_vgsteff)-1.0*V(f_nmtrans2_vbseff),2))-0.5000000000*V(f_nmtrans2_g_k1))   ;
 V(f_nmtrans2_vdseff_cv) <+
0.5*V(f_nmtrans2_vdsat_cv)+0.5*V(f_nmtrans2_vds)+0.10e-1-0.5*mysqrt(pow(V(f_nmtrans2_vdsat_cv)-1.0*V(f_nmtrans2_vds)-0.2e-1,2)+0.8e-1*V(f_nmtrans2_vdsat_cv))   ;
 V(f_nmtrans2_faktor_t1) <+
12.0*V(f_nmtrans2_vgsteff)-6.0*V(f_nmtrans2_abulk_cv)*V(f_nmtrans2_vdseff_cv)+0.12e-18   ;
 V(f_nmtrans2_qs_ohne_o) <+
-0.1151044334e-2*ota_mbsim3v3_nmtrans2_w*V(f_nmtrans2_leff_cv)*(V(f_nmtrans2_vgsteff)-0.5*V(f_nmtrans2_vdseff_cv)+V(f_nmtrans2_abulk_cv)*pow(V(f_nmtrans2_vdseff_cv),2)/V(f_nmtrans2_faktor_t1))-0.1151044334e-2*ota_mbsim3v3_nmtrans2_w*V(f_nmtrans2_leff_cv)*(1.0-1.0*V(f_nmtrans2_abulk_cv))*(0.5*V(f_nmtrans2_vdseff_cv)-1.0*V(f_nmtrans2_abulk_cv)*pow(V(f_nmtrans2_vdseff_cv),2)/V(f_nmtrans2_faktor_t1))   ;
 V(f_nmtrans2_g_qg) <+
0.2302088667e-2*ota_mbsim3v3_nmtrans2_w*V(f_nmtrans2_leff_cv)*(V(f_nmtrans2_vgsteff)-0.5*V(f_nmtrans2_vdseff_cv)+V(f_nmtrans2_abulk_cv)*pow(V(f_nmtrans2_vdseff_cv),2)/V(f_nmtrans2_faktor_t1))+V(f_nmtrans2_qac0)+V(f_nmtrans2_qsub0)   ;
 V(f_nmtrans2_qg) <+
V(f_nmtrans2_g_qg)+V(f_nmtrans2_qoverlap_s)+V(f_nmtrans2_qoverlap_d)   ;
 V(f_nmtrans2_g_qb) <+
0.2302088667e-2*ota_mbsim3v3_nmtrans2_w*V(f_nmtrans2_leff_cv)*(1.0-1.0*V(f_nmtrans2_abulk_cv))*(0.5*V(f_nmtrans2_vdseff_cv)-1.0*V(f_nmtrans2_abulk_cv)*pow(V(f_nmtrans2_vdseff_cv),2)/V(f_nmtrans2_faktor_t1))-1.0*V(f_nmtrans2_qac0)-1.0*V(f_nmtrans2_qsub0)   ;
 V(f_nmtrans2_qb) <+
V(f_nmtrans2_g_qb)   ;
 V(f_nmtrans2_g_qd) <+
-1.0*V(f_nmtrans2_g_qg)-1.0*V(f_nmtrans2_qs_ohne_o)-1.0*V(f_nmtrans2_g_qb)   ;
 V(f_nmtrans2_qd) <+
(1.0-1.0*V(f_nmtrans2_dir))*(V(f_nmtrans2_g_qd)-1.0*V(f_nmtrans2_qoverlap_d))+V(f_nmtrans2_dir)*(V(f_nmtrans2_qs_ohne_o)-1.0*V(f_nmtrans2_qoverlap_d))   ;
 V(f_nmtrans2_qs) <+
(1.0-1.0*V(f_nmtrans2_dir))*(V(f_nmtrans2_qs_ohne_o)-1.0*V(f_nmtrans2_qoverlap_s))+V(f_nmtrans2_dir)*(V(f_nmtrans2_g_qd)-1.0*V(f_nmtrans2_qoverlap_s))   ;
 V(f_nmtrans3_g_t) <+
_a98*$temperature-273.15+300.15-27.0*_a98   ;
 V(f_nmtrans3_g_ni) <+
0.2788434715e13*pow(V(f_nmtrans3_g_t),1.5)*exp(21.5565981-5802.261235*(1.16-0.702e-3*pow(V(f_nmtrans3_g_t),2)/(V(f_nmtrans3_g_t)+1108.0))/V(f_nmtrans3_g_t))   ;
 V(f_nmtrans3_g_k2) <+
0.4188640132*(1.777177754-0.1312808442e-1*mysqrt(V(f_nmtrans3_g_t)*ln(0.17e24/V(f_nmtrans3_g_ni))))/(0.2625616884e-1*mysqrt(V(f_nmtrans3_g_t)*ln(0.17e24/V(f_nmtrans3_g_ni))*(0.1723466006e-3*V(f_nmtrans3_g_t)*ln(0.17e24/V(f_nmtrans3_g_ni))+5.0))-0.3446932012e-3*V(f_nmtrans3_g_t)*ln(0.17e24/V(f_nmtrans3_g_ni))-5.0)   ;
 V(f_nmtrans3_g_k1) <+
0.6130457498-2.0*V(f_nmtrans3_g_k2)*mysqrt(0.1723466006e-3*V(f_nmtrans3_g_t)*ln(0.17e24/V(f_nmtrans3_g_ni))+5.0)   ;
 V(f_nmtrans3_vgsi) <+
V(nbias)-1.0*V(gnd)   ;
 V(f_nmtrans3_vdsi) <+
V(nbias)-1.0*V(gnd)   ;
 V(f_nmtrans3_vbsi) <+
0.0   ;
 V(f_nmtrans3_dir) <+
_a99-1.0*_a99*_a100*(V(f_nmtrans3_vdsi) >= 0 ?  1.0 : 0.0 )   ;
 V(f_nmtrans3_vgs) <+
(1.0-1.0*V(f_nmtrans3_dir))*V(f_nmtrans3_vgsi)+V(f_nmtrans3_dir)*(V(f_nmtrans3_vgsi)-1.0*V(f_nmtrans3_vdsi))   ;
 V(f_nmtrans3_vds) <+
(1.0-2.0*V(f_nmtrans3_dir))*V(f_nmtrans3_vdsi)   ;
 V(f_nmtrans3_vbs) <+
(1.0-1.0*V(f_nmtrans3_dir))*V(f_nmtrans3_vbsi)+V(f_nmtrans3_dir)*(V(f_nmtrans3_vbsi)-1.0*V(f_nmtrans3_vdsi))   ;
 V(f_nmtrans3_g_y) <+
0.1551119405e-3*V(f_nmtrans3_g_t)*ln(0.17e24/V(f_nmtrans3_g_ni))-0.9*pow(V(f_nmtrans3_g_k1),2)/(4.0*pow(V(f_nmtrans3_g_k2),2)+0.1e-24)   ;
 V(f_nmtrans3_vbc) <+
-8.99925+0.25*V(f_nmtrans3_g_y)+0.25*mysqrt(pow(-29.999-1.0*V(f_nmtrans3_g_y),2)+0.120)-0.5*mysqrt(pow(11.9985-0.5*V(f_nmtrans3_g_y)-0.5*mysqrt(pow(-29.999-1.0*V(f_nmtrans3_g_y),2)+0.120),2)+0.12e-1)   ;
 V(f_nmtrans3_vbseff) <+
_a103*V(f_nmtrans3_vbc)+0.5*_a104*_a103*(V(f_nmtrans3_vbs)-1.0*V(f_nmtrans3_vbc)-0.1e-2+mysqrt(pow(V(f_nmtrans3_vbs)-1.0*V(f_nmtrans3_vbc)-0.1e-2,2)-0.4e-2*V(f_nmtrans3_vbc)))+(1.0-1.0*_a103)*_a104*V(f_nmtrans3_vbs)   ;
 V(f_nmtrans3_sqrtphis) <+
0.1723466006e-3*V(f_nmtrans3_g_t)*ln(0.17e24/V(f_nmtrans3_g_ni))*mysqrt(0.1723466006e-3*V(f_nmtrans3_g_t)*ln(0.17e24/V(f_nmtrans3_g_ni))-1.0*_a101*(0.5*V(f_nmtrans3_vbseff)-0.5*mysqrt(pow(V(f_nmtrans3_vbseff),2))))/(0.1723466006e-3*V(f_nmtrans3_g_t)*ln(0.17e24/V(f_nmtrans3_g_ni))+0.5*_a102*(0.5*V(f_nmtrans3_vbseff)+0.5*mysqrt(pow(V(f_nmtrans3_vbseff),2))))   ;
 V(f_nmtrans3_leff) <+
ota_mbsim3v3_nmtrans3_l   ;
 V(f_nmtrans3_weff_strich) <+
ota_mbsim3v3_nmtrans3_w   ;
 V(f_nmtrans3_leff_cv) <+
ota_mbsim3v3_nmtrans3_l   ;
 V(f_nmtrans3_lt1) <+
0.6264792526e-7*mysqrt(V(f_nmtrans3_sqrtphis))*((-0.32e-1*V(f_nmtrans3_vbseff)+0.5 >= 0 ?  1.0 : 0.0 )*(1.0-0.32e-1*V(f_nmtrans3_vbseff))+1.0*(1.0-1.0*(-0.32e-1*V(f_nmtrans3_vbseff)+0.5 >= 0 ?  1.0 : 0.0 ))*(1.0-0.960e-1*V(f_nmtrans3_vbseff))/(3.0-0.2560*V(f_nmtrans3_vbseff)))   ;
 V(f_nmtrans3_theta0vb0) <+
exp(-69656657.50*V(f_nmtrans3_leff)*pow(V(f_nmtrans3_g_t)*ln(0.17e24/V(f_nmtrans3_g_ni)),-0.2500000000))+2.0*pow(exp(-69656657.50*V(f_nmtrans3_leff)*pow(V(f_nmtrans3_g_t)*ln(0.17e24/V(f_nmtrans3_g_ni)),-0.2500000000)),2)   ;
 V(f_nmtrans3_v0) <+
0.8617330030e-4*V(f_nmtrans3_g_t)*ln(0.17e50*pow(V(f_nmtrans3_g_ni),-2))-0.1723466006e-3*V(f_nmtrans3_g_t)*ln(0.17e24/V(f_nmtrans3_g_ni))   ;
 V(f_nmtrans3_delt_vth) <+
2.2*V(f_nmtrans3_v0)*exp(-0.265*V(f_nmtrans3_leff)/V(f_nmtrans3_lt1))*(1.0+2.0*exp(-0.265*V(f_nmtrans3_leff)/V(f_nmtrans3_lt1)))   ;
 V(f_nmtrans3_vth_t22) <+
0.0   ;
 V(f_nmtrans3_vth_t1_t1) <+
0.1312808442e-1*_a116*V(f_nmtrans3_g_k1)*(mysqrt(1.0+0.174e-6/V(f_nmtrans3_leff))-1.0)*mysqrt(V(f_nmtrans3_g_t)*ln(0.17e24/V(f_nmtrans3_g_ni)))+_a97*(-0.11+0.22e-1*V(f_nmtrans3_vbseff))*(0.3331667500e-2*V(f_nmtrans3_g_t)-1.0)   ;
 V(f_nmtrans3_vth) <+
ota_mbsim3v3_n_mos_vth0+_a118*(_a106*(-0.1312808442e-1*V(f_nmtrans3_g_k1)*mysqrt(V(f_nmtrans3_g_t)*ln(0.17e24/V(f_nmtrans3_g_ni)))+1.000000000*V(f_nmtrans3_g_k1)*V(f_nmtrans3_sqrtphis)-1.000000000*V(f_nmtrans3_g_k2)*V(f_nmtrans3_vbseff))-1.0*_a107*V(f_nmtrans3_delt_vth)-1.0*_a107*V(f_nmtrans3_vth_t22)+0.2068159207e-9*V(f_nmtrans3_g_t)*ln(0.17e24/V(f_nmtrans3_g_ni))/(V(f_nmtrans3_weff_strich)+0.25e-5)+V(f_nmtrans3_vth_t1_t1)-1.0*_a113*V(f_nmtrans3_vds)*V(f_nmtrans3_theta0vb0)*(0.8e-1-0.7e-1*V(f_nmtrans3_vbseff)))   ;
 V(f_nmtrans3_scvt) <+
exp(-4229988.446*V(f_nmtrans3_leff)*pow(V(f_nmtrans3_sqrtphis),-0.5000000000)/(1.0-0.32e-1*_a107*V(f_nmtrans3_vbseff)))+2.0*exp(-8459976.892*V(f_nmtrans3_leff)*pow(V(f_nmtrans3_sqrtphis),-0.5000000000)/(1.0-0.32e-1*_a107*V(f_nmtrans3_vbseff)))   ;
 V(f_nmtrans3_nvgs) <+
0.5159548816/V(f_nmtrans3_sqrtphis)+0.1042531521*_a107*V(f_nmtrans3_scvt)   ;
 V(f_nmtrans3_vgsteff) <+
(0.1723466006e-3*_a108*_a109*(V(f_nmtrans3_nvgs)+1.0)*V(f_nmtrans3_g_t)*ln(1.0+exp(5802.261235*(V(f_nmtrans3_vgs)-1.0*V(f_nmtrans3_vth))/(V(f_nmtrans3_nvgs)+1.0)/V(f_nmtrans3_g_t)))+(1.0-1.0*_a108)*_a109*(V(f_nmtrans3_vgs)-1.0*V(f_nmtrans3_vth)))/(1.0+0.5088849782e-1*_a108*_a109*(V(f_nmtrans3_nvgs)+1.0)*mysqrt(V(f_nmtrans3_g_t)*ln(0.17e24/V(f_nmtrans3_g_ni)))*exp(5802.261235*(-1.0*V(f_nmtrans3_vgs)+V(f_nmtrans3_vth)-0.16)/(V(f_nmtrans3_nvgs)+1.0)/V(f_nmtrans3_g_t)))   ;
 V(f_nmtrans3_weff) <+
ota_mbsim3v3_nmtrans3_w   ;
 V(f_nmtrans3_ueff) <+
0.670e-1/(1.0+_a119*(66666666.67*(0.225e-8-0.465e-10*_a106*V(f_nmtrans3_vbseff))*(V(f_nmtrans3_vgsteff)+2.0*V(f_nmtrans3_vth))+0.2608888889e-2*pow(V(f_nmtrans3_vgsteff)+2.0*V(f_nmtrans3_vth),2)))   ;
 V(f_nmtrans3_abulkp) <+
(1.0+0.5000000000*V(f_nmtrans3_g_k1)/V(f_nmtrans3_sqrtphis)*V(f_nmtrans3_leff)/(V(f_nmtrans3_leff)+0.2287578680e-6*mysqrt(V(f_nmtrans3_sqrtphis))))/(1.0-0.47e-1*V(f_nmtrans3_vbseff))   ;
 V(f_nmtrans3_abulk) <+
_a110*(0.5*V(f_nmtrans3_abulkp)+0.245e-1+0.5*mysqrt(pow(V(f_nmtrans3_abulkp)-0.51e-1,2)+0.4e-2))+(1.0-1.0*_a110)*V(f_nmtrans3_abulkp)   ;
 V(f_nmtrans3_temp3) <+
0.160e6*(V(f_nmtrans3_vgsteff)+0.1723466006e-3*_a115*V(f_nmtrans3_g_t))/V(f_nmtrans3_ueff)*V(f_nmtrans3_leff)   ;
 V(f_nmtrans3_temp2) <+
-1.000000000*V(f_nmtrans3_vgsteff)-0.1723466006e-3*_a115*V(f_nmtrans3_g_t)-0.160e6*V(f_nmtrans3_abulk)/V(f_nmtrans3_ueff)*V(f_nmtrans3_leff)   ;
 V(f_nmtrans3_vdsat) <+
0.160e6/V(f_nmtrans3_ueff)*V(f_nmtrans3_leff)*(V(f_nmtrans3_vgsteff)+0.1723466006e-3*_a115*V(f_nmtrans3_g_t))/(0.160e6*V(f_nmtrans3_abulk)/V(f_nmtrans3_ueff)*V(f_nmtrans3_leff)+_a117*(V(f_nmtrans3_vgsteff)+0.1723466006e-3*_a115*V(f_nmtrans3_g_t)))   ;
 V(f_nmtrans3_vdseff) <+
_a112*V(f_nmtrans3_vdsat)-0.5*_a111*_a112*(V(f_nmtrans3_vdsat)-1.0*V(f_nmtrans3_vds)-0.1e-1+mysqrt(pow(V(f_nmtrans3_vdsat)-1.0*V(f_nmtrans3_vds)-0.1e-1,2)+0.4e-1*V(f_nmtrans3_vdsat)))+(1.0-1.0*_a112)*_a111*V(f_nmtrans3_vds)   ;
 V(f_nmtrans3_vasat_t9) <+
0.0   ;
 V(f_nmtrans3_vasat_t0) <+
0.160e6/V(f_nmtrans3_ueff)*V(f_nmtrans3_leff)+V(f_nmtrans3_vdsat)+2.0*V(f_nmtrans3_vasat_t9)*(1.0-0.5*V(f_nmtrans3_abulk)*V(f_nmtrans3_vdsat)/(V(f_nmtrans3_vgsteff)+0.17234174e-3*_a115*V(f_nmtrans3_g_t)))   ;
 V(f_nmtrans3_vasat) <+
1.000000000*V(f_nmtrans3_vasat_t0)   ;
 V(f_nmtrans3_e_vascbe) <+
0.10e-4*_a112/V(f_nmtrans3_leff)*exp(-34.83515634/(V(f_nmtrans3_vds)-1.0*V(f_nmtrans3_vdseff)+0.1e-9))   ;
 V(f_nmtrans3_vadiblc) <+
(V(f_nmtrans3_vgsteff)+0.1723466006e-3*_a115*V(f_nmtrans3_g_t))/(0.39*exp(-39007728.23*V(f_nmtrans3_leff)*pow(V(f_nmtrans3_g_t)*ln(0.17e24/V(f_nmtrans3_g_ni)),-0.2500000000))+0.78*exp(-78015456.46*V(f_nmtrans3_leff)*pow(V(f_nmtrans3_g_t)*ln(0.17e24/V(f_nmtrans3_g_ni)),-0.2500000000))+0.86e-2)*(1.0-1.0*V(f_nmtrans3_abulk)*V(f_nmtrans3_vdsat)/(V(f_nmtrans3_abulk)*V(f_nmtrans3_vdsat)+V(f_nmtrans3_vgsteff)+0.1723466006e-3*_a115*V(f_nmtrans3_g_t)))   ;
 V(f_nmtrans3_vaclm) <+
9362778.307*_a112*V(f_nmtrans3_leff)*(V(f_nmtrans3_abulk)+0.6250000000e-5*_a117*V(f_nmtrans3_vgsteff)*V(f_nmtrans3_ueff)/V(f_nmtrans3_leff))/V(f_nmtrans3_abulk)*(V(f_nmtrans3_vds)-1.0*V(f_nmtrans3_vdseff)+0.1e-9)+0.1e-9-0.1e-9*_a112   ;
 V(f_nmtrans3_vafaktor) <+
_a113*_a114/(1.0/V(f_nmtrans3_vaclm)+1.0/V(f_nmtrans3_vadiblc))+(1.0-1.0*_a113)*_a114*V(f_nmtrans3_vaclm)+_a113*(1.0-1.0*_a114)*V(f_nmtrans3_vadiblc)   ;
 V(f_nmtrans3_va) <+
V(f_nmtrans3_vasat)+V(f_nmtrans3_vafaktor)   ;
 V(f_nmtrans3_idso) <+
0.2302088667e-2*V(f_nmtrans3_weff)*V(f_nmtrans3_ueff)*V(f_nmtrans3_vgsteff)*(1.0-1.0*V(f_nmtrans3_abulk)*V(f_nmtrans3_vdseff)/(2.0*V(f_nmtrans3_vgsteff)+0.3446932012e-3*_a115*V(f_nmtrans3_g_t)))*V(f_nmtrans3_vdseff)/V(f_nmtrans3_leff)/(1.0+0.6250000000e-5*_a117*V(f_nmtrans3_vdseff)*V(f_nmtrans3_ueff)/V(f_nmtrans3_leff))   ;
 V(f_nmtrans3_idsx) <+
V(f_nmtrans3_idso)*(1.0+_a112*_a105*(V(f_nmtrans3_vds)-1.0*V(f_nmtrans3_vdseff))*V(f_nmtrans3_e_vascbe))*(1.0+_a112*(_a113+_a114-0.5 >= 0 ?  1.0 : 0.0 )*(V(f_nmtrans3_vds)-1.0*V(f_nmtrans3_vdseff))/V(f_nmtrans3_va))   ;
 V(f_nmtrans3_ids) <+
(1.0-2.0*V(f_nmtrans3_dir))*V(f_nmtrans3_idsx)   ;
 V(f_nmtrans3_cgdo_strich) <+
0.2801776464e-9*ota_mbsim3v3_nmtrans3_w   ;
 V(f_nmtrans3_cgso_strich) <+
0.2801776464e-9*ota_mbsim3v3_nmtrans3_w   ;
 V(f_nmtrans3_echte_vgd) <+
V(f_nmtrans3_vgsi)-1.0*V(f_nmtrans3_vdsi)   ;
 V(f_nmtrans3_echte_vgs) <+
V(f_nmtrans3_vgsi)   ;
 V(f_nmtrans3_echte_vgb) <+
V(f_nmtrans3_vgsi)-1.0*V(f_nmtrans3_vbsi)   ;
 V(f_nmtrans3_qgdo_T0) <+
V(f_nmtrans3_echte_vgd)+0.2e-1   ;
 V(f_nmtrans3_qgdo_T1) <+
mysqrt(pow(V(f_nmtrans3_qgdo_T0),2)+0.8e-1)   ;
 V(f_nmtrans3_qgdo_T2) <+
0.5*V(f_nmtrans3_qgdo_T0)-0.5*V(f_nmtrans3_qgdo_T1)   ;
 V(f_nmtrans3_qgdo_T3) <+
0.0   ;
 V(f_nmtrans3_qgdo_T4) <+
mysqrt(1.0-6.666666668*V(f_nmtrans3_qgdo_T2))   ;
 V(f_nmtrans3_qgso_T0) <+
V(f_nmtrans3_echte_vgs)+0.2e-1   ;
 V(f_nmtrans3_qgso_T1) <+
mysqrt(pow(V(f_nmtrans3_qgso_T0),2)+0.8e-1)   ;
 V(f_nmtrans3_qgso_T2) <+
0.5*V(f_nmtrans3_qgso_T0)-0.5*V(f_nmtrans3_qgso_T1)   ;
 V(f_nmtrans3_qgso_T3) <+
0.0   ;
 V(f_nmtrans3_qgso_T4) <+
mysqrt(1.0-6.666666668*V(f_nmtrans3_qgso_T2))   ;
 V(f_nmtrans3_qoverlap_d) <+
(V(f_nmtrans3_cgdo_strich)+V(f_nmtrans3_qgdo_T3))*V(f_nmtrans3_echte_vgd)-1.0*V(f_nmtrans3_qgdo_T3)*(V(f_nmtrans3_qgdo_T2)+0.30*V(f_nmtrans3_qgdo_T4)-0.300)   ;
 V(f_nmtrans3_qoverlap_s) <+
(V(f_nmtrans3_cgso_strich)+V(f_nmtrans3_qgso_T3))*V(f_nmtrans3_echte_vgs)-1.0*V(f_nmtrans3_qgso_T3)*(V(f_nmtrans3_qgso_T2)+0.30*V(f_nmtrans3_qgso_T4)-0.300)   ;
 V(f_nmtrans3_v3) <+
ota_mbsim3v3_n_mos_vth0-0.1723466006e-3*V(f_nmtrans3_g_t)*ln(0.17e24/V(f_nmtrans3_g_ni))-0.1312808442e-1*V(f_nmtrans3_g_k1)*mysqrt(V(f_nmtrans3_g_t)*ln(0.17e24/V(f_nmtrans3_g_ni)))-1.0*V(f_nmtrans3_vgs)+V(f_nmtrans3_vbseff)-0.2e-1   ;
 V(f_nmtrans3_vfbeff) <+
ota_mbsim3v3_n_mos_vth0-0.1723466006e-3*V(f_nmtrans3_g_t)*ln(0.17e24/V(f_nmtrans3_g_ni))-0.1312808442e-1*V(f_nmtrans3_g_k1)*mysqrt(V(f_nmtrans3_g_t)*ln(0.17e24/V(f_nmtrans3_g_ni)))-0.5*V(f_nmtrans3_v3)-0.5*mysqrt(pow(V(f_nmtrans3_v3),2)+0.8e-1*mysqrt(pow(ota_mbsim3v3_n_mos_vth0-0.1723466006e-3*V(f_nmtrans3_g_t)*ln(0.17e24/V(f_nmtrans3_g_ni))-0.1312808442e-1*V(f_nmtrans3_g_k1)*mysqrt(V(f_nmtrans3_g_t)*ln(0.17e24/V(f_nmtrans3_g_ni))),2)))   ;
 V(f_nmtrans3_qac0) <+
0.2302088667e-2*ota_mbsim3v3_nmtrans3_w*V(f_nmtrans3_leff_cv)*(V(f_nmtrans3_vfbeff)-1.0*ota_mbsim3v3_n_mos_vth0+0.1723466006e-3*V(f_nmtrans3_g_t)*ln(0.17e24/V(f_nmtrans3_g_ni))+0.1312808442e-1*V(f_nmtrans3_g_k1)*mysqrt(V(f_nmtrans3_g_t)*ln(0.17e24/V(f_nmtrans3_g_ni))))   ;
 V(f_nmtrans3_abulk_cv) <+
(0.5*(1.0+0.5000000000*V(f_nmtrans3_g_k1)/V(f_nmtrans3_sqrtphis)*V(f_nmtrans3_leff)/(V(f_nmtrans3_leff)+0.2287578680e-6*mysqrt(V(f_nmtrans3_sqrtphis))))/(1.0-0.47e-1*V(f_nmtrans3_vbseff))+0.245e-1+0.5*mysqrt(pow((1.0+0.5000000000*V(f_nmtrans3_g_k1)/V(f_nmtrans3_sqrtphis)*V(f_nmtrans3_leff)/(V(f_nmtrans3_leff)+0.2287578680e-6*mysqrt(V(f_nmtrans3_sqrtphis))))/(1.0-0.47e-1*V(f_nmtrans3_vbseff))-0.51e-1,2)+0.4e-2))*(1.0+0.6309573445e-4*pow(1.0/V(f_nmtrans3_leff),0.6))   ;
 V(f_nmtrans3_vdsat_cv) <+
V(f_nmtrans3_vgsteff)/V(f_nmtrans3_abulk_cv)   ;
 V(f_nmtrans3_qsub0) <+
0.2302088667e-2*ota_mbsim3v3_nmtrans3_w*V(f_nmtrans3_leff_cv)*V(f_nmtrans3_g_k1)*(pow(pow(0.2500000000*pow(V(f_nmtrans3_g_k1),2)+0.5*V(f_nmtrans3_vgs)-0.5*V(f_nmtrans3_vfbeff)-0.5*V(f_nmtrans3_vgsteff)-0.5*V(f_nmtrans3_vbseff)+0.5*mysqrt(pow(V(f_nmtrans3_vgs)-1.0*V(f_nmtrans3_vfbeff)-1.0*V(f_nmtrans3_vgsteff)-1.0*V(f_nmtrans3_vbseff),2)),2),0.2500000000)+0.5*V(f_nmtrans3_vgs)-0.5*V(f_nmtrans3_vfbeff)-0.5*V(f_nmtrans3_vgsteff)-0.5*V(f_nmtrans3_vbseff)-0.5*mysqrt(pow(V(f_nmtrans3_vgs)-1.0*V(f_nmtrans3_vfbeff)-1.0*V(f_nmtrans3_vgsteff)-1.0*V(f_nmtrans3_vbseff),2))-0.5000000000*V(f_nmtrans3_g_k1))   ;
 V(f_nmtrans3_vdseff_cv) <+
0.5*V(f_nmtrans3_vdsat_cv)+0.5*V(f_nmtrans3_vds)+0.10e-1-0.5*mysqrt(pow(V(f_nmtrans3_vdsat_cv)-1.0*V(f_nmtrans3_vds)-0.2e-1,2)+0.8e-1*V(f_nmtrans3_vdsat_cv))   ;
 V(f_nmtrans3_faktor_t1) <+
12.0*V(f_nmtrans3_vgsteff)-6.0*V(f_nmtrans3_abulk_cv)*V(f_nmtrans3_vdseff_cv)+0.12e-18   ;
 V(f_nmtrans3_qs_ohne_o) <+
-0.1151044334e-2*ota_mbsim3v3_nmtrans3_w*V(f_nmtrans3_leff_cv)*(V(f_nmtrans3_vgsteff)-0.5*V(f_nmtrans3_vdseff_cv)+V(f_nmtrans3_abulk_cv)*pow(V(f_nmtrans3_vdseff_cv),2)/V(f_nmtrans3_faktor_t1))-0.1151044334e-2*ota_mbsim3v3_nmtrans3_w*V(f_nmtrans3_leff_cv)*(1.0-1.0*V(f_nmtrans3_abulk_cv))*(0.5*V(f_nmtrans3_vdseff_cv)-1.0*V(f_nmtrans3_abulk_cv)*pow(V(f_nmtrans3_vdseff_cv),2)/V(f_nmtrans3_faktor_t1))   ;
 V(f_nmtrans3_g_qg) <+
0.2302088667e-2*ota_mbsim3v3_nmtrans3_w*V(f_nmtrans3_leff_cv)*(V(f_nmtrans3_vgsteff)-0.5*V(f_nmtrans3_vdseff_cv)+V(f_nmtrans3_abulk_cv)*pow(V(f_nmtrans3_vdseff_cv),2)/V(f_nmtrans3_faktor_t1))+V(f_nmtrans3_qac0)+V(f_nmtrans3_qsub0)   ;
 V(f_nmtrans3_qg) <+
V(f_nmtrans3_g_qg)+V(f_nmtrans3_qoverlap_s)+V(f_nmtrans3_qoverlap_d)   ;
 V(f_nmtrans3_g_qb) <+
0.2302088667e-2*ota_mbsim3v3_nmtrans3_w*V(f_nmtrans3_leff_cv)*(1.0-1.0*V(f_nmtrans3_abulk_cv))*(0.5*V(f_nmtrans3_vdseff_cv)-1.0*V(f_nmtrans3_abulk_cv)*pow(V(f_nmtrans3_vdseff_cv),2)/V(f_nmtrans3_faktor_t1))-1.0*V(f_nmtrans3_qac0)-1.0*V(f_nmtrans3_qsub0)   ;
 V(f_nmtrans3_qb) <+
V(f_nmtrans3_g_qb)   ;
 V(f_nmtrans3_g_qd) <+
-1.0*V(f_nmtrans3_g_qg)-1.0*V(f_nmtrans3_qs_ohne_o)-1.0*V(f_nmtrans3_g_qb)   ;
 V(f_nmtrans3_qd) <+
(1.0-1.0*V(f_nmtrans3_dir))*(V(f_nmtrans3_g_qd)-1.0*V(f_nmtrans3_qoverlap_d))+V(f_nmtrans3_dir)*(V(f_nmtrans3_qs_ohne_o)-1.0*V(f_nmtrans3_qoverlap_d))   ;
 V(f_nmtrans3_qs) <+
(1.0-1.0*V(f_nmtrans3_dir))*(V(f_nmtrans3_qs_ohne_o)-1.0*V(f_nmtrans3_qoverlap_s))+V(f_nmtrans3_dir)*(V(f_nmtrans3_g_qd)-1.0*V(f_nmtrans3_qoverlap_s))   ;
 V(f_pmbtrans9_g_t) <+
_a122*$temperature-273.15+300.15-27.0*_a122   ;
 V(f_pmbtrans9_g_ni) <+
0.2788434715e13*pow(V(f_pmbtrans9_g_t),1.5)*exp(21.5565981-5802.261235*(1.16-0.702e-3*pow(V(f_pmbtrans9_g_t),2)/(V(f_pmbtrans9_g_t)+1108.0))/V(f_pmbtrans9_g_t))   ;
 V(f_pmbtrans9_g_k2) <+
0.4188640132*(1.777177754-0.1312808442e-1*mysqrt(V(f_pmbtrans9_g_t)*ln(0.17e24/V(f_pmbtrans9_g_ni))))/(0.2625616884e-1*mysqrt(V(f_pmbtrans9_g_t)*ln(0.17e24/V(f_pmbtrans9_g_ni))*(0.1723466006e-3*V(f_pmbtrans9_g_t)*ln(0.17e24/V(f_pmbtrans9_g_ni))+5.0))-0.3446932012e-3*V(f_pmbtrans9_g_t)*ln(0.17e24/V(f_pmbtrans9_g_ni))-5.0)   ;
 V(f_pmbtrans9_g_k1) <+
0.6130457498-2.0*V(f_pmbtrans9_g_k2)*mysqrt(0.1723466006e-3*V(f_pmbtrans9_g_t)*ln(0.17e24/V(f_pmbtrans9_g_ni))+5.0)   ;
 V(f_pmbtrans9_vgsi) <+
V(p_in)-1.0*V(pbias)   ;
 V(f_pmbtrans9_vdsi) <+
V(u_int1)-1.0*V(pbias)   ;
 V(f_pmbtrans9_vbsi) <+
V(vdd)-1.0*V(pbias)   ;
 V(f_pmbtrans9_dir) <+
_a123-1.0*_a123*_a124*(-1.0*V(f_pmbtrans9_vdsi) >= 0 ?  1.0 : 0.0 )   ;
 V(f_pmbtrans9_vgs) <+
-1.0*(1.0-1.0*V(f_pmbtrans9_dir))*V(f_pmbtrans9_vgsi)-1.0*V(f_pmbtrans9_dir)*(V(f_pmbtrans9_vgsi)-1.0*V(f_pmbtrans9_vdsi))   ;
 V(f_pmbtrans9_vds) <+
-1.0*(1.0-2.0*V(f_pmbtrans9_dir))*V(f_pmbtrans9_vdsi)   ;
 V(f_pmbtrans9_vbs) <+
-1.0*(1.0-1.0*V(f_pmbtrans9_dir))*V(f_pmbtrans9_vbsi)-1.0*V(f_pmbtrans9_dir)*(V(f_pmbtrans9_vbsi)-1.0*V(f_pmbtrans9_vdsi))   ;
 V(f_pmbtrans9_g_y) <+
0.1551119405e-3*V(f_pmbtrans9_g_t)*ln(0.17e24/V(f_pmbtrans9_g_ni))-0.9*pow(V(f_pmbtrans9_g_k1),2)/(4.0*pow(V(f_pmbtrans9_g_k2),2)+0.1e-24)   ;
 V(f_pmbtrans9_vbc) <+
-8.99925+0.25*V(f_pmbtrans9_g_y)+0.25*mysqrt(pow(-29.999-1.0*V(f_pmbtrans9_g_y),2)+0.120)-0.5*mysqrt(pow(11.9985-0.5*V(f_pmbtrans9_g_y)-0.5*mysqrt(pow(-29.999-1.0*V(f_pmbtrans9_g_y),2)+0.120),2)+0.12e-1)   ;
 V(f_pmbtrans9_vbseff) <+
_a127*V(f_pmbtrans9_vbc)+0.5*_a128*_a127*(V(f_pmbtrans9_vbs)-1.0*V(f_pmbtrans9_vbc)-0.1e-2+mysqrt(pow(V(f_pmbtrans9_vbs)-1.0*V(f_pmbtrans9_vbc)-0.1e-2,2)-0.4e-2*V(f_pmbtrans9_vbc)))+(1.0-1.0*_a127)*_a128*V(f_pmbtrans9_vbs)   ;
 V(f_pmbtrans9_sqrtphis) <+
0.1723466006e-3*V(f_pmbtrans9_g_t)*ln(0.17e24/V(f_pmbtrans9_g_ni))*mysqrt(0.1723466006e-3*V(f_pmbtrans9_g_t)*ln(0.17e24/V(f_pmbtrans9_g_ni))-1.0*_a125*(0.5*V(f_pmbtrans9_vbseff)-0.5*mysqrt(pow(V(f_pmbtrans9_vbseff),2))))/(0.1723466006e-3*V(f_pmbtrans9_g_t)*ln(0.17e24/V(f_pmbtrans9_g_ni))+0.5*_a126*(0.5*V(f_pmbtrans9_vbseff)+0.5*mysqrt(pow(V(f_pmbtrans9_vbseff),2))))   ;
 V(f_pmbtrans9_leff) <+
ota_mbsim3v3_pmbtrans9_l   ;
 V(f_pmbtrans9_weff_strich) <+
ota_mbsim3v3_pmbtrans9_w   ;
 V(f_pmbtrans9_leff_cv) <+
ota_mbsim3v3_pmbtrans9_l   ;
 V(f_pmbtrans9_lt1) <+
0.6264792526e-7*mysqrt(V(f_pmbtrans9_sqrtphis))*((-0.32e-1*V(f_pmbtrans9_vbseff)+0.5 >= 0 ?  1.0 : 0.0 )*(1.0-0.32e-1*V(f_pmbtrans9_vbseff))+1.0*(1.0-1.0*(-0.32e-1*V(f_pmbtrans9_vbseff)+0.5 >= 0 ?  1.0 : 0.0 ))*(1.0-0.960e-1*V(f_pmbtrans9_vbseff))/(3.0-0.2560*V(f_pmbtrans9_vbseff)))   ;
 V(f_pmbtrans9_theta0vb0) <+
exp(-69656657.50*V(f_pmbtrans9_leff)*pow(V(f_pmbtrans9_g_t)*ln(0.17e24/V(f_pmbtrans9_g_ni)),-0.2500000000))+2.0*pow(exp(-69656657.50*V(f_pmbtrans9_leff)*pow(V(f_pmbtrans9_g_t)*ln(0.17e24/V(f_pmbtrans9_g_ni)),-0.2500000000)),2)   ;
 V(f_pmbtrans9_v0) <+
0.8617330030e-4*V(f_pmbtrans9_g_t)*ln(0.17e50*pow(V(f_pmbtrans9_g_ni),-2))-0.1723466006e-3*V(f_pmbtrans9_g_t)*ln(0.17e24/V(f_pmbtrans9_g_ni))   ;
 V(f_pmbtrans9_delt_vth) <+
2.2*V(f_pmbtrans9_v0)*exp(-0.265*V(f_pmbtrans9_leff)/V(f_pmbtrans9_lt1))*(1.0+2.0*exp(-0.265*V(f_pmbtrans9_leff)/V(f_pmbtrans9_lt1)))   ;
 V(f_pmbtrans9_vth_t22) <+
0.0   ;
 V(f_pmbtrans9_vth_t1_t1) <+
0.1312808442e-1*_a140*V(f_pmbtrans9_g_k1)*(mysqrt(1.0+0.174e-6/V(f_pmbtrans9_leff))-1.0)*mysqrt(V(f_pmbtrans9_g_t)*ln(0.17e24/V(f_pmbtrans9_g_ni)))+_a121*(-0.11+0.22e-1*V(f_pmbtrans9_vbseff))*(0.3331667500e-2*V(f_pmbtrans9_g_t)-1.0)   ;
 V(f_pmbtrans9_vth) <+
-1.0*ota_mbsim3v3_p_mos_vth0+_a142*(_a130*(-0.1312808442e-1*V(f_pmbtrans9_g_k1)*mysqrt(V(f_pmbtrans9_g_t)*ln(0.17e24/V(f_pmbtrans9_g_ni)))+1.000000000*V(f_pmbtrans9_g_k1)*V(f_pmbtrans9_sqrtphis)-1.000000000*V(f_pmbtrans9_g_k2)*V(f_pmbtrans9_vbseff))-1.0*_a131*V(f_pmbtrans9_delt_vth)-1.0*_a131*V(f_pmbtrans9_vth_t22)+0.2068159207e-9*V(f_pmbtrans9_g_t)*ln(0.17e24/V(f_pmbtrans9_g_ni))/(V(f_pmbtrans9_weff_strich)+0.25e-5)+V(f_pmbtrans9_vth_t1_t1)-1.0*_a137*V(f_pmbtrans9_vds)*V(f_pmbtrans9_theta0vb0)*(0.8e-1-0.7e-1*V(f_pmbtrans9_vbseff)))   ;
 V(f_pmbtrans9_scvt) <+
exp(-4229988.446*V(f_pmbtrans9_leff)*pow(V(f_pmbtrans9_sqrtphis),-0.5000000000)/(1.0-0.32e-1*_a131*V(f_pmbtrans9_vbseff)))+2.0*exp(-8459976.892*V(f_pmbtrans9_leff)*pow(V(f_pmbtrans9_sqrtphis),-0.5000000000)/(1.0-0.32e-1*_a131*V(f_pmbtrans9_vbseff)))   ;
 V(f_pmbtrans9_nvgs) <+
0.5159548816/V(f_pmbtrans9_sqrtphis)+0.1042531521*_a131*V(f_pmbtrans9_scvt)   ;
 V(f_pmbtrans9_vgsteff) <+
(0.1723466006e-3*_a132*_a133*(V(f_pmbtrans9_nvgs)+1.0)*V(f_pmbtrans9_g_t)*ln(1.0+exp(5802.261235*(V(f_pmbtrans9_vgs)-1.0*V(f_pmbtrans9_vth))/(V(f_pmbtrans9_nvgs)+1.0)/V(f_pmbtrans9_g_t)))+(1.0-1.0*_a132)*_a133*(V(f_pmbtrans9_vgs)-1.0*V(f_pmbtrans9_vth)))/(1.0+0.5088849782e-1*_a132*_a133*(V(f_pmbtrans9_nvgs)+1.0)*mysqrt(V(f_pmbtrans9_g_t)*ln(0.17e24/V(f_pmbtrans9_g_ni)))*exp(5802.261235*(-1.0*V(f_pmbtrans9_vgs)+V(f_pmbtrans9_vth)-0.16)/(V(f_pmbtrans9_nvgs)+1.0)/V(f_pmbtrans9_g_t)))   ;
 V(f_pmbtrans9_weff) <+
ota_mbsim3v3_pmbtrans9_w   ;
 V(f_pmbtrans9_ueff) <+
0.670e-1/(1.0+_a143*(66666666.67*(0.225e-8-0.465e-10*_a130*V(f_pmbtrans9_vbseff))*(V(f_pmbtrans9_vgsteff)+2.0*V(f_pmbtrans9_vth))+0.2608888889e-2*pow(V(f_pmbtrans9_vgsteff)+2.0*V(f_pmbtrans9_vth),2)))   ;
 V(f_pmbtrans9_abulkp) <+
(1.0+0.5000000000*V(f_pmbtrans9_g_k1)/V(f_pmbtrans9_sqrtphis)*V(f_pmbtrans9_leff)/(V(f_pmbtrans9_leff)+0.2287578680e-6*mysqrt(V(f_pmbtrans9_sqrtphis))))/(1.0-0.47e-1*V(f_pmbtrans9_vbseff))   ;
 V(f_pmbtrans9_abulk) <+
_a134*(0.5*V(f_pmbtrans9_abulkp)+0.245e-1+0.5*mysqrt(pow(V(f_pmbtrans9_abulkp)-0.51e-1,2)+0.4e-2))+(1.0-1.0*_a134)*V(f_pmbtrans9_abulkp)   ;
 V(f_pmbtrans9_temp3) <+
0.160e6*(V(f_pmbtrans9_vgsteff)+0.1723466006e-3*_a139*V(f_pmbtrans9_g_t))/V(f_pmbtrans9_ueff)*V(f_pmbtrans9_leff)   ;
 V(f_pmbtrans9_temp2) <+
-1.000000000*V(f_pmbtrans9_vgsteff)-0.1723466006e-3*_a139*V(f_pmbtrans9_g_t)-0.160e6*V(f_pmbtrans9_abulk)/V(f_pmbtrans9_ueff)*V(f_pmbtrans9_leff)   ;
 V(f_pmbtrans9_vdsat) <+
0.160e6/V(f_pmbtrans9_ueff)*V(f_pmbtrans9_leff)*(V(f_pmbtrans9_vgsteff)+0.1723466006e-3*_a139*V(f_pmbtrans9_g_t))/(0.160e6*V(f_pmbtrans9_abulk)/V(f_pmbtrans9_ueff)*V(f_pmbtrans9_leff)+_a141*(V(f_pmbtrans9_vgsteff)+0.1723466006e-3*_a139*V(f_pmbtrans9_g_t)))   ;
 V(f_pmbtrans9_vdseff) <+
_a136*V(f_pmbtrans9_vdsat)-0.5*_a135*_a136*(V(f_pmbtrans9_vdsat)-1.0*V(f_pmbtrans9_vds)-0.1e-1+mysqrt(pow(V(f_pmbtrans9_vdsat)-1.0*V(f_pmbtrans9_vds)-0.1e-1,2)+0.4e-1*V(f_pmbtrans9_vdsat)))+(1.0-1.0*_a136)*_a135*V(f_pmbtrans9_vds)   ;
 V(f_pmbtrans9_vasat_t9) <+
0.0   ;
 V(f_pmbtrans9_vasat_t0) <+
0.160e6/V(f_pmbtrans9_ueff)*V(f_pmbtrans9_leff)+V(f_pmbtrans9_vdsat)+2.0*V(f_pmbtrans9_vasat_t9)*(1.0-0.5*V(f_pmbtrans9_abulk)*V(f_pmbtrans9_vdsat)/(V(f_pmbtrans9_vgsteff)+0.17234174e-3*_a139*V(f_pmbtrans9_g_t)))   ;
 V(f_pmbtrans9_vasat) <+
1.000000000*V(f_pmbtrans9_vasat_t0)   ;
 V(f_pmbtrans9_e_vascbe) <+
0.10e-4*_a136/V(f_pmbtrans9_leff)*exp(-34.83515634/(V(f_pmbtrans9_vds)-1.0*V(f_pmbtrans9_vdseff)+0.1e-9))   ;
 V(f_pmbtrans9_vadiblc) <+
(V(f_pmbtrans9_vgsteff)+0.1723466006e-3*_a139*V(f_pmbtrans9_g_t))/(0.39*exp(-39007728.23*V(f_pmbtrans9_leff)*pow(V(f_pmbtrans9_g_t)*ln(0.17e24/V(f_pmbtrans9_g_ni)),-0.2500000000))+0.78*exp(-78015456.46*V(f_pmbtrans9_leff)*pow(V(f_pmbtrans9_g_t)*ln(0.17e24/V(f_pmbtrans9_g_ni)),-0.2500000000))+0.86e-2)*(1.0-1.0*V(f_pmbtrans9_abulk)*V(f_pmbtrans9_vdsat)/(V(f_pmbtrans9_abulk)*V(f_pmbtrans9_vdsat)+V(f_pmbtrans9_vgsteff)+0.1723466006e-3*_a139*V(f_pmbtrans9_g_t)))   ;
 V(f_pmbtrans9_vaclm) <+
9362778.307*_a136*V(f_pmbtrans9_leff)*(V(f_pmbtrans9_abulk)+0.6250000000e-5*_a141*V(f_pmbtrans9_vgsteff)*V(f_pmbtrans9_ueff)/V(f_pmbtrans9_leff))/V(f_pmbtrans9_abulk)*(V(f_pmbtrans9_vds)-1.0*V(f_pmbtrans9_vdseff)+0.1e-9)+0.1e-9-0.1e-9*_a136   ;
 V(f_pmbtrans9_vafaktor) <+
_a137*_a138/(1.0/V(f_pmbtrans9_vaclm)+1.0/V(f_pmbtrans9_vadiblc))+(1.0-1.0*_a137)*_a138*V(f_pmbtrans9_vaclm)+_a137*(1.0-1.0*_a138)*V(f_pmbtrans9_vadiblc)   ;
 V(f_pmbtrans9_va) <+
V(f_pmbtrans9_vasat)+V(f_pmbtrans9_vafaktor)   ;
 V(f_pmbtrans9_idso) <+
0.2302088667e-2*V(f_pmbtrans9_weff)*V(f_pmbtrans9_ueff)*V(f_pmbtrans9_vgsteff)*(1.0-1.0*V(f_pmbtrans9_abulk)*V(f_pmbtrans9_vdseff)/(2.0*V(f_pmbtrans9_vgsteff)+0.3446932012e-3*_a139*V(f_pmbtrans9_g_t)))*V(f_pmbtrans9_vdseff)/V(f_pmbtrans9_leff)/(1.0+0.6250000000e-5*_a141*V(f_pmbtrans9_vdseff)*V(f_pmbtrans9_ueff)/V(f_pmbtrans9_leff))   ;
 V(f_pmbtrans9_idsx) <+
V(f_pmbtrans9_idso)*(1.0+_a136*_a129*(V(f_pmbtrans9_vds)-1.0*V(f_pmbtrans9_vdseff))*V(f_pmbtrans9_e_vascbe))*(1.0+_a136*(_a137+_a138-0.5 >= 0 ?  1.0 : 0.0 )*(V(f_pmbtrans9_vds)-1.0*V(f_pmbtrans9_vdseff))/V(f_pmbtrans9_va))   ;
 V(f_pmbtrans9_ids) <+
(1.0-2.0*V(f_pmbtrans9_dir))*V(f_pmbtrans9_idsx)   ;
 V(f_pmbtrans9_cgdo_strich) <+
0.2801776464e-9*ota_mbsim3v3_pmbtrans9_w   ;
 V(f_pmbtrans9_cgso_strich) <+
0.2801776464e-9*ota_mbsim3v3_pmbtrans9_w   ;
 V(f_pmbtrans9_echte_vgd) <+
-1.0*V(f_pmbtrans9_vgsi)+V(f_pmbtrans9_vdsi)   ;
 V(f_pmbtrans9_echte_vgs) <+
-1.0*V(f_pmbtrans9_vgsi)   ;
 V(f_pmbtrans9_echte_vgb) <+
-1.0*V(f_pmbtrans9_vgsi)+V(f_pmbtrans9_vbsi)   ;
 V(f_pmbtrans9_qgdo_T0) <+
V(f_pmbtrans9_echte_vgd)+0.2e-1   ;
 V(f_pmbtrans9_qgdo_T1) <+
mysqrt(pow(V(f_pmbtrans9_qgdo_T0),2)+0.8e-1)   ;
 V(f_pmbtrans9_qgdo_T2) <+
0.5*V(f_pmbtrans9_qgdo_T0)-0.5*V(f_pmbtrans9_qgdo_T1)   ;
 V(f_pmbtrans9_qgdo_T3) <+
0.0   ;
 V(f_pmbtrans9_qgdo_T4) <+
mysqrt(1.0-6.666666668*V(f_pmbtrans9_qgdo_T2))   ;
 V(f_pmbtrans9_qgso_T0) <+
V(f_pmbtrans9_echte_vgs)+0.2e-1   ;
 V(f_pmbtrans9_qgso_T1) <+
mysqrt(pow(V(f_pmbtrans9_qgso_T0),2)+0.8e-1)   ;
 V(f_pmbtrans9_qgso_T2) <+
0.5*V(f_pmbtrans9_qgso_T0)-0.5*V(f_pmbtrans9_qgso_T1)   ;
 V(f_pmbtrans9_qgso_T3) <+
0.0   ;
 V(f_pmbtrans9_qgso_T4) <+
mysqrt(1.0-6.666666668*V(f_pmbtrans9_qgso_T2))   ;
 V(f_pmbtrans9_qoverlap_d) <+
(V(f_pmbtrans9_cgdo_strich)+V(f_pmbtrans9_qgdo_T3))*V(f_pmbtrans9_echte_vgd)-1.0*V(f_pmbtrans9_qgdo_T3)*(V(f_pmbtrans9_qgdo_T2)+0.30*V(f_pmbtrans9_qgdo_T4)-0.300)   ;
 V(f_pmbtrans9_qoverlap_s) <+
(V(f_pmbtrans9_cgso_strich)+V(f_pmbtrans9_qgso_T3))*V(f_pmbtrans9_echte_vgs)-1.0*V(f_pmbtrans9_qgso_T3)*(V(f_pmbtrans9_qgso_T2)+0.30*V(f_pmbtrans9_qgso_T4)-0.300)   ;
 V(f_pmbtrans9_v3) <+
-1.0*ota_mbsim3v3_p_mos_vth0-0.1723466006e-3*V(f_pmbtrans9_g_t)*ln(0.17e24/V(f_pmbtrans9_g_ni))-0.1312808442e-1*V(f_pmbtrans9_g_k1)*mysqrt(V(f_pmbtrans9_g_t)*ln(0.17e24/V(f_pmbtrans9_g_ni)))-1.0*V(f_pmbtrans9_vgs)+V(f_pmbtrans9_vbseff)-0.2e-1   ;
 V(f_pmbtrans9_vfbeff) <+
-1.0*ota_mbsim3v3_p_mos_vth0-0.1723466006e-3*V(f_pmbtrans9_g_t)*ln(0.17e24/V(f_pmbtrans9_g_ni))-0.1312808442e-1*V(f_pmbtrans9_g_k1)*mysqrt(V(f_pmbtrans9_g_t)*ln(0.17e24/V(f_pmbtrans9_g_ni)))-0.5*V(f_pmbtrans9_v3)-0.5*mysqrt(pow(V(f_pmbtrans9_v3),2)+0.8e-1*mysqrt(pow(-1.0*ota_mbsim3v3_p_mos_vth0-0.1723466006e-3*V(f_pmbtrans9_g_t)*ln(0.17e24/V(f_pmbtrans9_g_ni))-0.1312808442e-1*V(f_pmbtrans9_g_k1)*mysqrt(V(f_pmbtrans9_g_t)*ln(0.17e24/V(f_pmbtrans9_g_ni))),2)))   ;
 V(f_pmbtrans9_qac0) <+
0.2302088667e-2*ota_mbsim3v3_pmbtrans9_w*V(f_pmbtrans9_leff_cv)*(V(f_pmbtrans9_vfbeff)+ota_mbsim3v3_p_mos_vth0+0.1723466006e-3*V(f_pmbtrans9_g_t)*ln(0.17e24/V(f_pmbtrans9_g_ni))+0.1312808442e-1*V(f_pmbtrans9_g_k1)*mysqrt(V(f_pmbtrans9_g_t)*ln(0.17e24/V(f_pmbtrans9_g_ni))))   ;
 V(f_pmbtrans9_abulk_cv) <+
(0.5*(1.0+0.5000000000*V(f_pmbtrans9_g_k1)/V(f_pmbtrans9_sqrtphis)*V(f_pmbtrans9_leff)/(V(f_pmbtrans9_leff)+0.2287578680e-6*mysqrt(V(f_pmbtrans9_sqrtphis))))/(1.0-0.47e-1*V(f_pmbtrans9_vbseff))+0.245e-1+0.5*mysqrt(pow((1.0+0.5000000000*V(f_pmbtrans9_g_k1)/V(f_pmbtrans9_sqrtphis)*V(f_pmbtrans9_leff)/(V(f_pmbtrans9_leff)+0.2287578680e-6*mysqrt(V(f_pmbtrans9_sqrtphis))))/(1.0-0.47e-1*V(f_pmbtrans9_vbseff))-0.51e-1,2)+0.4e-2))*(1.0+0.6309573445e-4*pow(1.0/V(f_pmbtrans9_leff),0.6))   ;
 V(f_pmbtrans9_vdsat_cv) <+
V(f_pmbtrans9_vgsteff)/V(f_pmbtrans9_abulk_cv)   ;
 V(f_pmbtrans9_qsub0) <+
0.2302088667e-2*ota_mbsim3v3_pmbtrans9_w*V(f_pmbtrans9_leff_cv)*V(f_pmbtrans9_g_k1)*(pow(pow(0.2500000000*pow(V(f_pmbtrans9_g_k1),2)+0.5*V(f_pmbtrans9_vgs)-0.5*V(f_pmbtrans9_vfbeff)-0.5*V(f_pmbtrans9_vgsteff)-0.5*V(f_pmbtrans9_vbseff)+0.5*mysqrt(pow(V(f_pmbtrans9_vgs)-1.0*V(f_pmbtrans9_vfbeff)-1.0*V(f_pmbtrans9_vgsteff)-1.0*V(f_pmbtrans9_vbseff),2)),2),0.2500000000)+0.5*V(f_pmbtrans9_vgs)-0.5*V(f_pmbtrans9_vfbeff)-0.5*V(f_pmbtrans9_vgsteff)-0.5*V(f_pmbtrans9_vbseff)-0.5*mysqrt(pow(V(f_pmbtrans9_vgs)-1.0*V(f_pmbtrans9_vfbeff)-1.0*V(f_pmbtrans9_vgsteff)-1.0*V(f_pmbtrans9_vbseff),2))-0.5000000000*V(f_pmbtrans9_g_k1))   ;
 V(f_pmbtrans9_vdseff_cv) <+
0.5*V(f_pmbtrans9_vdsat_cv)+0.5*V(f_pmbtrans9_vds)+0.10e-1-0.5*mysqrt(pow(V(f_pmbtrans9_vdsat_cv)-1.0*V(f_pmbtrans9_vds)-0.2e-1,2)+0.8e-1*V(f_pmbtrans9_vdsat_cv))   ;
 V(f_pmbtrans9_faktor_t1) <+
12.0*V(f_pmbtrans9_vgsteff)-6.0*V(f_pmbtrans9_abulk_cv)*V(f_pmbtrans9_vdseff_cv)+0.12e-18   ;
 V(f_pmbtrans9_qs_ohne_o) <+
-0.1151044334e-2*ota_mbsim3v3_pmbtrans9_w*V(f_pmbtrans9_leff_cv)*(V(f_pmbtrans9_vgsteff)-0.5*V(f_pmbtrans9_vdseff_cv)+V(f_pmbtrans9_abulk_cv)*pow(V(f_pmbtrans9_vdseff_cv),2)/V(f_pmbtrans9_faktor_t1))-0.1151044334e-2*ota_mbsim3v3_pmbtrans9_w*V(f_pmbtrans9_leff_cv)*(1.0-1.0*V(f_pmbtrans9_abulk_cv))*(0.5*V(f_pmbtrans9_vdseff_cv)-1.0*V(f_pmbtrans9_abulk_cv)*pow(V(f_pmbtrans9_vdseff_cv),2)/V(f_pmbtrans9_faktor_t1))   ;
 V(f_pmbtrans9_g_qg) <+
0.2302088667e-2*ota_mbsim3v3_pmbtrans9_w*V(f_pmbtrans9_leff_cv)*(V(f_pmbtrans9_vgsteff)-0.5*V(f_pmbtrans9_vdseff_cv)+V(f_pmbtrans9_abulk_cv)*pow(V(f_pmbtrans9_vdseff_cv),2)/V(f_pmbtrans9_faktor_t1))+V(f_pmbtrans9_qac0)+V(f_pmbtrans9_qsub0)   ;
 V(f_pmbtrans9_qg) <+
V(f_pmbtrans9_g_qg)+V(f_pmbtrans9_qoverlap_s)+V(f_pmbtrans9_qoverlap_d)   ;
 V(f_pmbtrans9_g_qb) <+
0.2302088667e-2*ota_mbsim3v3_pmbtrans9_w*V(f_pmbtrans9_leff_cv)*(1.0-1.0*V(f_pmbtrans9_abulk_cv))*(0.5*V(f_pmbtrans9_vdseff_cv)-1.0*V(f_pmbtrans9_abulk_cv)*pow(V(f_pmbtrans9_vdseff_cv),2)/V(f_pmbtrans9_faktor_t1))-1.0*V(f_pmbtrans9_qac0)-1.0*V(f_pmbtrans9_qsub0)   ;
 V(f_pmbtrans9_qb) <+
V(f_pmbtrans9_g_qb)   ;
 V(f_pmbtrans9_g_qd) <+
-1.0*V(f_pmbtrans9_g_qg)-1.0*V(f_pmbtrans9_qs_ohne_o)-1.0*V(f_pmbtrans9_g_qb)   ;
 V(f_pmbtrans9_qd) <+
(1.0-1.0*V(f_pmbtrans9_dir))*(V(f_pmbtrans9_g_qd)-1.0*V(f_pmbtrans9_qoverlap_d))+V(f_pmbtrans9_dir)*(V(f_pmbtrans9_qs_ohne_o)-1.0*V(f_pmbtrans9_qoverlap_d))   ;
 V(f_pmbtrans9_qs) <+
(1.0-1.0*V(f_pmbtrans9_dir))*(V(f_pmbtrans9_qs_ohne_o)-1.0*V(f_pmbtrans9_qoverlap_s))+V(f_pmbtrans9_dir)*(V(f_pmbtrans9_g_qd)-1.0*V(f_pmbtrans9_qoverlap_s))   ;
 V(f_pmbtrans20_g_t) <+
_a146*$temperature-273.15+300.15-27.0*_a146   ;
 V(f_pmbtrans20_g_ni) <+
0.2788434715e13*pow(V(f_pmbtrans20_g_t),1.5)*exp(21.5565981-5802.261235*(1.16-0.702e-3*pow(V(f_pmbtrans20_g_t),2)/(V(f_pmbtrans20_g_t)+1108.0))/V(f_pmbtrans20_g_t))   ;
 V(f_pmbtrans20_g_k2) <+
0.4188640132*(1.777177754-0.1312808442e-1*mysqrt(V(f_pmbtrans20_g_t)*ln(0.17e24/V(f_pmbtrans20_g_ni))))/(0.2625616884e-1*mysqrt(V(f_pmbtrans20_g_t)*ln(0.17e24/V(f_pmbtrans20_g_ni))*(0.1723466006e-3*V(f_pmbtrans20_g_t)*ln(0.17e24/V(f_pmbtrans20_g_ni))+5.0))-0.3446932012e-3*V(f_pmbtrans20_g_t)*ln(0.17e24/V(f_pmbtrans20_g_ni))-5.0)   ;
 V(f_pmbtrans20_g_k1) <+
0.6130457498-2.0*V(f_pmbtrans20_g_k2)*mysqrt(0.1723466006e-3*V(f_pmbtrans20_g_t)*ln(0.17e24/V(f_pmbtrans20_g_ni))+5.0)   ;
 V(f_pmbtrans20_vgsi) <+
V(n_in)-1.0*V(pbias)   ;
 V(f_pmbtrans20_vdsi) <+
V(out1)-1.0*V(pbias)   ;
 V(f_pmbtrans20_vbsi) <+
V(vdd)-1.0*V(pbias)   ;
 V(f_pmbtrans20_dir) <+
_a147-1.0*_a147*_a148*(-1.0*V(f_pmbtrans20_vdsi) >= 0 ?  1.0 : 0.0 )   ;
 V(f_pmbtrans20_vgs) <+
-1.0*(1.0-1.0*V(f_pmbtrans20_dir))*V(f_pmbtrans20_vgsi)-1.0*V(f_pmbtrans20_dir)*(V(f_pmbtrans20_vgsi)-1.0*V(f_pmbtrans20_vdsi))   ;
 V(f_pmbtrans20_vds) <+
-1.0*(1.0-2.0*V(f_pmbtrans20_dir))*V(f_pmbtrans20_vdsi)   ;
 V(f_pmbtrans20_vbs) <+
-1.0*(1.0-1.0*V(f_pmbtrans20_dir))*V(f_pmbtrans20_vbsi)-1.0*V(f_pmbtrans20_dir)*(V(f_pmbtrans20_vbsi)-1.0*V(f_pmbtrans20_vdsi))   ;
 V(f_pmbtrans20_g_y) <+
0.1551119405e-3*V(f_pmbtrans20_g_t)*ln(0.17e24/V(f_pmbtrans20_g_ni))-0.9*pow(V(f_pmbtrans20_g_k1),2)/(4.0*pow(V(f_pmbtrans20_g_k2),2)+0.1e-24)   ;
 V(f_pmbtrans20_vbc) <+
-8.99925+0.25*V(f_pmbtrans20_g_y)+0.25*mysqrt(pow(-29.999-1.0*V(f_pmbtrans20_g_y),2)+0.120)-0.5*mysqrt(pow(11.9985-0.5*V(f_pmbtrans20_g_y)-0.5*mysqrt(pow(-29.999-1.0*V(f_pmbtrans20_g_y),2)+0.120),2)+0.12e-1)   ;
 V(f_pmbtrans20_vbseff) <+
_a151*V(f_pmbtrans20_vbc)+0.5*_a152*_a151*(V(f_pmbtrans20_vbs)-1.0*V(f_pmbtrans20_vbc)-0.1e-2+mysqrt(pow(V(f_pmbtrans20_vbs)-1.0*V(f_pmbtrans20_vbc)-0.1e-2,2)-0.4e-2*V(f_pmbtrans20_vbc)))+(1.0-1.0*_a151)*_a152*V(f_pmbtrans20_vbs)   ;
 V(f_pmbtrans20_sqrtphis) <+
0.1723466006e-3*V(f_pmbtrans20_g_t)*ln(0.17e24/V(f_pmbtrans20_g_ni))*mysqrt(0.1723466006e-3*V(f_pmbtrans20_g_t)*ln(0.17e24/V(f_pmbtrans20_g_ni))-1.0*_a149*(0.5*V(f_pmbtrans20_vbseff)-0.5*mysqrt(pow(V(f_pmbtrans20_vbseff),2))))/(0.1723466006e-3*V(f_pmbtrans20_g_t)*ln(0.17e24/V(f_pmbtrans20_g_ni))+0.5*_a150*(0.5*V(f_pmbtrans20_vbseff)+0.5*mysqrt(pow(V(f_pmbtrans20_vbseff),2))))   ;
 V(f_pmbtrans20_leff) <+
ota_mbsim3v3_pmbtrans20_l   ;
 V(f_pmbtrans20_weff_strich) <+
ota_mbsim3v3_pmbtrans20_w   ;
 V(f_pmbtrans20_leff_cv) <+
ota_mbsim3v3_pmbtrans20_l   ;
 V(f_pmbtrans20_lt1) <+
0.6264792526e-7*mysqrt(V(f_pmbtrans20_sqrtphis))*((-0.32e-1*V(f_pmbtrans20_vbseff)+0.5 >= 0 ?  1.0 : 0.0 )*(1.0-0.32e-1*V(f_pmbtrans20_vbseff))+1.0*(1.0-1.0*(-0.32e-1*V(f_pmbtrans20_vbseff)+0.5 >= 0 ?  1.0 : 0.0 ))*(1.0-0.960e-1*V(f_pmbtrans20_vbseff))/(3.0-0.2560*V(f_pmbtrans20_vbseff)))   ;
 V(f_pmbtrans20_theta0vb0) <+
exp(-69656657.50*V(f_pmbtrans20_leff)*pow(V(f_pmbtrans20_g_t)*ln(0.17e24/V(f_pmbtrans20_g_ni)),-0.2500000000))+2.0*pow(exp(-69656657.50*V(f_pmbtrans20_leff)*pow(V(f_pmbtrans20_g_t)*ln(0.17e24/V(f_pmbtrans20_g_ni)),-0.2500000000)),2)   ;
 V(f_pmbtrans20_v0) <+
0.8617330030e-4*V(f_pmbtrans20_g_t)*ln(0.17e50*pow(V(f_pmbtrans20_g_ni),-2))-0.1723466006e-3*V(f_pmbtrans20_g_t)*ln(0.17e24/V(f_pmbtrans20_g_ni))   ;
 V(f_pmbtrans20_delt_vth) <+
2.2*V(f_pmbtrans20_v0)*exp(-0.265*V(f_pmbtrans20_leff)/V(f_pmbtrans20_lt1))*(1.0+2.0*exp(-0.265*V(f_pmbtrans20_leff)/V(f_pmbtrans20_lt1)))   ;
 V(f_pmbtrans20_vth_t22) <+
0.0   ;
 V(f_pmbtrans20_vth_t1_t1) <+
0.1312808442e-1*_a164*V(f_pmbtrans20_g_k1)*(mysqrt(1.0+0.174e-6/V(f_pmbtrans20_leff))-1.0)*mysqrt(V(f_pmbtrans20_g_t)*ln(0.17e24/V(f_pmbtrans20_g_ni)))+_a145*(-0.11+0.22e-1*V(f_pmbtrans20_vbseff))*(0.3331667500e-2*V(f_pmbtrans20_g_t)-1.0)   ;
 V(f_pmbtrans20_vth) <+
-1.0*ota_mbsim3v3_p_mos_vth0+_a166*(_a154*(-0.1312808442e-1*V(f_pmbtrans20_g_k1)*mysqrt(V(f_pmbtrans20_g_t)*ln(0.17e24/V(f_pmbtrans20_g_ni)))+1.000000000*V(f_pmbtrans20_g_k1)*V(f_pmbtrans20_sqrtphis)-1.000000000*V(f_pmbtrans20_g_k2)*V(f_pmbtrans20_vbseff))-1.0*_a155*V(f_pmbtrans20_delt_vth)-1.0*_a155*V(f_pmbtrans20_vth_t22)+0.2068159207e-9*V(f_pmbtrans20_g_t)*ln(0.17e24/V(f_pmbtrans20_g_ni))/(V(f_pmbtrans20_weff_strich)+0.25e-5)+V(f_pmbtrans20_vth_t1_t1)-1.0*_a161*V(f_pmbtrans20_vds)*V(f_pmbtrans20_theta0vb0)*(0.8e-1-0.7e-1*V(f_pmbtrans20_vbseff)))   ;
 V(f_pmbtrans20_scvt) <+
exp(-4229988.446*V(f_pmbtrans20_leff)*pow(V(f_pmbtrans20_sqrtphis),-0.5000000000)/(1.0-0.32e-1*_a155*V(f_pmbtrans20_vbseff)))+2.0*exp(-8459976.892*V(f_pmbtrans20_leff)*pow(V(f_pmbtrans20_sqrtphis),-0.5000000000)/(1.0-0.32e-1*_a155*V(f_pmbtrans20_vbseff)))   ;
 V(f_pmbtrans20_nvgs) <+
0.5159548816/V(f_pmbtrans20_sqrtphis)+0.1042531521*_a155*V(f_pmbtrans20_scvt)   ;
 V(f_pmbtrans20_vgsteff) <+
(0.1723466006e-3*_a156*_a157*(V(f_pmbtrans20_nvgs)+1.0)*V(f_pmbtrans20_g_t)*ln(1.0+exp(5802.261235*(V(f_pmbtrans20_vgs)-1.0*V(f_pmbtrans20_vth))/(V(f_pmbtrans20_nvgs)+1.0)/V(f_pmbtrans20_g_t)))+(1.0-1.0*_a156)*_a157*(V(f_pmbtrans20_vgs)-1.0*V(f_pmbtrans20_vth)))/(1.0+0.5088849782e-1*_a156*_a157*(V(f_pmbtrans20_nvgs)+1.0)*mysqrt(V(f_pmbtrans20_g_t)*ln(0.17e24/V(f_pmbtrans20_g_ni)))*exp(5802.261235*(-1.0*V(f_pmbtrans20_vgs)+V(f_pmbtrans20_vth)-0.16)/(V(f_pmbtrans20_nvgs)+1.0)/V(f_pmbtrans20_g_t)))   ;
 V(f_pmbtrans20_weff) <+
ota_mbsim3v3_pmbtrans20_w   ;
 V(f_pmbtrans20_ueff) <+
0.670e-1/(1.0+_a167*(66666666.67*(0.225e-8-0.465e-10*_a154*V(f_pmbtrans20_vbseff))*(V(f_pmbtrans20_vgsteff)+2.0*V(f_pmbtrans20_vth))+0.2608888889e-2*pow(V(f_pmbtrans20_vgsteff)+2.0*V(f_pmbtrans20_vth),2)))   ;
 V(f_pmbtrans20_abulkp) <+
(1.0+0.5000000000*V(f_pmbtrans20_g_k1)/V(f_pmbtrans20_sqrtphis)*V(f_pmbtrans20_leff)/(V(f_pmbtrans20_leff)+0.2287578680e-6*mysqrt(V(f_pmbtrans20_sqrtphis))))/(1.0-0.47e-1*V(f_pmbtrans20_vbseff))   ;
 V(f_pmbtrans20_abulk) <+
_a158*(0.5*V(f_pmbtrans20_abulkp)+0.245e-1+0.5*mysqrt(pow(V(f_pmbtrans20_abulkp)-0.51e-1,2)+0.4e-2))+(1.0-1.0*_a158)*V(f_pmbtrans20_abulkp)   ;
 V(f_pmbtrans20_temp3) <+
0.160e6*(V(f_pmbtrans20_vgsteff)+0.1723466006e-3*_a163*V(f_pmbtrans20_g_t))/V(f_pmbtrans20_ueff)*V(f_pmbtrans20_leff)   ;
 V(f_pmbtrans20_temp2) <+
-1.000000000*V(f_pmbtrans20_vgsteff)-0.1723466006e-3*_a163*V(f_pmbtrans20_g_t)-0.160e6*V(f_pmbtrans20_abulk)/V(f_pmbtrans20_ueff)*V(f_pmbtrans20_leff)   ;
 V(f_pmbtrans20_vdsat) <+
0.160e6/V(f_pmbtrans20_ueff)*V(f_pmbtrans20_leff)*(V(f_pmbtrans20_vgsteff)+0.1723466006e-3*_a163*V(f_pmbtrans20_g_t))/(0.160e6*V(f_pmbtrans20_abulk)/V(f_pmbtrans20_ueff)*V(f_pmbtrans20_leff)+_a165*(V(f_pmbtrans20_vgsteff)+0.1723466006e-3*_a163*V(f_pmbtrans20_g_t)))   ;
 V(f_pmbtrans20_vdseff) <+
_a160*V(f_pmbtrans20_vdsat)-0.5*_a159*_a160*(V(f_pmbtrans20_vdsat)-1.0*V(f_pmbtrans20_vds)-0.1e-1+mysqrt(pow(V(f_pmbtrans20_vdsat)-1.0*V(f_pmbtrans20_vds)-0.1e-1,2)+0.4e-1*V(f_pmbtrans20_vdsat)))+(1.0-1.0*_a160)*_a159*V(f_pmbtrans20_vds)   ;
 V(f_pmbtrans20_vasat_t9) <+
0.0   ;
 V(f_pmbtrans20_vasat_t0) <+
0.160e6/V(f_pmbtrans20_ueff)*V(f_pmbtrans20_leff)+V(f_pmbtrans20_vdsat)+2.0*V(f_pmbtrans20_vasat_t9)*(1.0-0.5*V(f_pmbtrans20_abulk)*V(f_pmbtrans20_vdsat)/(V(f_pmbtrans20_vgsteff)+0.17234174e-3*_a163*V(f_pmbtrans20_g_t)))   ;
 V(f_pmbtrans20_vasat) <+
1.000000000*V(f_pmbtrans20_vasat_t0)   ;
 V(f_pmbtrans20_e_vascbe) <+
0.10e-4*_a160/V(f_pmbtrans20_leff)*exp(-34.83515634/(V(f_pmbtrans20_vds)-1.0*V(f_pmbtrans20_vdseff)+0.1e-9))   ;
 V(f_pmbtrans20_vadiblc) <+
(V(f_pmbtrans20_vgsteff)+0.1723466006e-3*_a163*V(f_pmbtrans20_g_t))/(0.39*exp(-39007728.23*V(f_pmbtrans20_leff)*pow(V(f_pmbtrans20_g_t)*ln(0.17e24/V(f_pmbtrans20_g_ni)),-0.2500000000))+0.78*exp(-78015456.46*V(f_pmbtrans20_leff)*pow(V(f_pmbtrans20_g_t)*ln(0.17e24/V(f_pmbtrans20_g_ni)),-0.2500000000))+0.86e-2)*(1.0-1.0*V(f_pmbtrans20_abulk)*V(f_pmbtrans20_vdsat)/(V(f_pmbtrans20_abulk)*V(f_pmbtrans20_vdsat)+V(f_pmbtrans20_vgsteff)+0.1723466006e-3*_a163*V(f_pmbtrans20_g_t)))   ;
 V(f_pmbtrans20_vaclm) <+
9362778.307*_a160*V(f_pmbtrans20_leff)*(V(f_pmbtrans20_abulk)+0.6250000000e-5*_a165*V(f_pmbtrans20_vgsteff)*V(f_pmbtrans20_ueff)/V(f_pmbtrans20_leff))/V(f_pmbtrans20_abulk)*(V(f_pmbtrans20_vds)-1.0*V(f_pmbtrans20_vdseff)+0.1e-9)+0.1e-9-0.1e-9*_a160   ;
 V(f_pmbtrans20_vafaktor) <+
_a161*_a162/(1.0/V(f_pmbtrans20_vaclm)+1.0/V(f_pmbtrans20_vadiblc))+(1.0-1.0*_a161)*_a162*V(f_pmbtrans20_vaclm)+_a161*(1.0-1.0*_a162)*V(f_pmbtrans20_vadiblc)   ;
 V(f_pmbtrans20_va) <+
V(f_pmbtrans20_vasat)+V(f_pmbtrans20_vafaktor)   ;
 V(f_pmbtrans20_idso) <+
0.2302088667e-2*V(f_pmbtrans20_weff)*V(f_pmbtrans20_ueff)*V(f_pmbtrans20_vgsteff)*(1.0-1.0*V(f_pmbtrans20_abulk)*V(f_pmbtrans20_vdseff)/(2.0*V(f_pmbtrans20_vgsteff)+0.3446932012e-3*_a163*V(f_pmbtrans20_g_t)))*V(f_pmbtrans20_vdseff)/V(f_pmbtrans20_leff)/(1.0+0.6250000000e-5*_a165*V(f_pmbtrans20_vdseff)*V(f_pmbtrans20_ueff)/V(f_pmbtrans20_leff))   ;
 V(f_pmbtrans20_idsx) <+
V(f_pmbtrans20_idso)*(1.0+_a160*_a153*(V(f_pmbtrans20_vds)-1.0*V(f_pmbtrans20_vdseff))*V(f_pmbtrans20_e_vascbe))*(1.0+_a160*(_a161+_a162-0.5 >= 0 ?  1.0 : 0.0 )*(V(f_pmbtrans20_vds)-1.0*V(f_pmbtrans20_vdseff))/V(f_pmbtrans20_va))   ;
 V(f_pmbtrans20_ids) <+
(1.0-2.0*V(f_pmbtrans20_dir))*V(f_pmbtrans20_idsx)   ;
 V(f_pmbtrans20_cgdo_strich) <+
0.2801776464e-9*ota_mbsim3v3_pmbtrans20_w   ;
 V(f_pmbtrans20_cgso_strich) <+
0.2801776464e-9*ota_mbsim3v3_pmbtrans20_w   ;
 V(f_pmbtrans20_echte_vgd) <+
-1.0*V(f_pmbtrans20_vgsi)+V(f_pmbtrans20_vdsi)   ;
 V(f_pmbtrans20_echte_vgs) <+
-1.0*V(f_pmbtrans20_vgsi)   ;
 V(f_pmbtrans20_echte_vgb) <+
-1.0*V(f_pmbtrans20_vgsi)+V(f_pmbtrans20_vbsi)   ;
 V(f_pmbtrans20_qgdo_T0) <+
V(f_pmbtrans20_echte_vgd)+0.2e-1   ;
 V(f_pmbtrans20_qgdo_T1) <+
mysqrt(pow(V(f_pmbtrans20_qgdo_T0),2)+0.8e-1)   ;
 V(f_pmbtrans20_qgdo_T2) <+
0.5*V(f_pmbtrans20_qgdo_T0)-0.5*V(f_pmbtrans20_qgdo_T1)   ;
 V(f_pmbtrans20_qgdo_T3) <+
0.0   ;
 V(f_pmbtrans20_qgdo_T4) <+
mysqrt(1.0-6.666666668*V(f_pmbtrans20_qgdo_T2))   ;
 V(f_pmbtrans20_qgso_T0) <+
V(f_pmbtrans20_echte_vgs)+0.2e-1   ;
 V(f_pmbtrans20_qgso_T1) <+
mysqrt(pow(V(f_pmbtrans20_qgso_T0),2)+0.8e-1)   ;
 V(f_pmbtrans20_qgso_T2) <+
0.5*V(f_pmbtrans20_qgso_T0)-0.5*V(f_pmbtrans20_qgso_T1)   ;
 V(f_pmbtrans20_qgso_T3) <+
0.0   ;
 V(f_pmbtrans20_qgso_T4) <+
mysqrt(1.0-6.666666668*V(f_pmbtrans20_qgso_T2))   ;
 V(f_pmbtrans20_qoverlap_d) <+
(V(f_pmbtrans20_cgdo_strich)+V(f_pmbtrans20_qgdo_T3))*V(f_pmbtrans20_echte_vgd)-1.0*V(f_pmbtrans20_qgdo_T3)*(V(f_pmbtrans20_qgdo_T2)+0.30*V(f_pmbtrans20_qgdo_T4)-0.300)   ;
 V(f_pmbtrans20_qoverlap_s) <+
(V(f_pmbtrans20_cgso_strich)+V(f_pmbtrans20_qgso_T3))*V(f_pmbtrans20_echte_vgs)-1.0*V(f_pmbtrans20_qgso_T3)*(V(f_pmbtrans20_qgso_T2)+0.30*V(f_pmbtrans20_qgso_T4)-0.300)   ;
 V(f_pmbtrans20_v3) <+
-1.0*ota_mbsim3v3_p_mos_vth0-0.1723466006e-3*V(f_pmbtrans20_g_t)*ln(0.17e24/V(f_pmbtrans20_g_ni))-0.1312808442e-1*V(f_pmbtrans20_g_k1)*mysqrt(V(f_pmbtrans20_g_t)*ln(0.17e24/V(f_pmbtrans20_g_ni)))-1.0*V(f_pmbtrans20_vgs)+V(f_pmbtrans20_vbseff)-0.2e-1   ;
 V(f_pmbtrans20_vfbeff) <+
-1.0*ota_mbsim3v3_p_mos_vth0-0.1723466006e-3*V(f_pmbtrans20_g_t)*ln(0.17e24/V(f_pmbtrans20_g_ni))-0.1312808442e-1*V(f_pmbtrans20_g_k1)*mysqrt(V(f_pmbtrans20_g_t)*ln(0.17e24/V(f_pmbtrans20_g_ni)))-0.5*V(f_pmbtrans20_v3)-0.5*mysqrt(pow(V(f_pmbtrans20_v3),2)+0.8e-1*mysqrt(pow(-1.0*ota_mbsim3v3_p_mos_vth0-0.1723466006e-3*V(f_pmbtrans20_g_t)*ln(0.17e24/V(f_pmbtrans20_g_ni))-0.1312808442e-1*V(f_pmbtrans20_g_k1)*mysqrt(V(f_pmbtrans20_g_t)*ln(0.17e24/V(f_pmbtrans20_g_ni))),2)))   ;
 V(f_pmbtrans20_qac0) <+
0.2302088667e-2*ota_mbsim3v3_pmbtrans20_w*V(f_pmbtrans20_leff_cv)*(V(f_pmbtrans20_vfbeff)+ota_mbsim3v3_p_mos_vth0+0.1723466006e-3*V(f_pmbtrans20_g_t)*ln(0.17e24/V(f_pmbtrans20_g_ni))+0.1312808442e-1*V(f_pmbtrans20_g_k1)*mysqrt(V(f_pmbtrans20_g_t)*ln(0.17e24/V(f_pmbtrans20_g_ni))))   ;
 V(f_pmbtrans20_abulk_cv) <+
(0.5*(1.0+0.5000000000*V(f_pmbtrans20_g_k1)/V(f_pmbtrans20_sqrtphis)*V(f_pmbtrans20_leff)/(V(f_pmbtrans20_leff)+0.2287578680e-6*mysqrt(V(f_pmbtrans20_sqrtphis))))/(1.0-0.47e-1*V(f_pmbtrans20_vbseff))+0.245e-1+0.5*mysqrt(pow((1.0+0.5000000000*V(f_pmbtrans20_g_k1)/V(f_pmbtrans20_sqrtphis)*V(f_pmbtrans20_leff)/(V(f_pmbtrans20_leff)+0.2287578680e-6*mysqrt(V(f_pmbtrans20_sqrtphis))))/(1.0-0.47e-1*V(f_pmbtrans20_vbseff))-0.51e-1,2)+0.4e-2))*(1.0+0.6309573445e-4*pow(1.0/V(f_pmbtrans20_leff),0.6))   ;
 V(f_pmbtrans20_vdsat_cv) <+
V(f_pmbtrans20_vgsteff)/V(f_pmbtrans20_abulk_cv)   ;
 V(f_pmbtrans20_qsub0) <+
0.2302088667e-2*ota_mbsim3v3_pmbtrans20_w*V(f_pmbtrans20_leff_cv)*V(f_pmbtrans20_g_k1)*(pow(pow(0.2500000000*pow(V(f_pmbtrans20_g_k1),2)+0.5*V(f_pmbtrans20_vgs)-0.5*V(f_pmbtrans20_vfbeff)-0.5*V(f_pmbtrans20_vgsteff)-0.5*V(f_pmbtrans20_vbseff)+0.5*mysqrt(pow(V(f_pmbtrans20_vgs)-1.0*V(f_pmbtrans20_vfbeff)-1.0*V(f_pmbtrans20_vgsteff)-1.0*V(f_pmbtrans20_vbseff),2)),2),0.2500000000)+0.5*V(f_pmbtrans20_vgs)-0.5*V(f_pmbtrans20_vfbeff)-0.5*V(f_pmbtrans20_vgsteff)-0.5*V(f_pmbtrans20_vbseff)-0.5*mysqrt(pow(V(f_pmbtrans20_vgs)-1.0*V(f_pmbtrans20_vfbeff)-1.0*V(f_pmbtrans20_vgsteff)-1.0*V(f_pmbtrans20_vbseff),2))-0.5000000000*V(f_pmbtrans20_g_k1))   ;
 V(f_pmbtrans20_vdseff_cv) <+
0.5*V(f_pmbtrans20_vdsat_cv)+0.5*V(f_pmbtrans20_vds)+0.10e-1-0.5*mysqrt(pow(V(f_pmbtrans20_vdsat_cv)-1.0*V(f_pmbtrans20_vds)-0.2e-1,2)+0.8e-1*V(f_pmbtrans20_vdsat_cv))   ;
 V(f_pmbtrans20_faktor_t1) <+
12.0*V(f_pmbtrans20_vgsteff)-6.0*V(f_pmbtrans20_abulk_cv)*V(f_pmbtrans20_vdseff_cv)+0.12e-18   ;
 V(f_pmbtrans20_qs_ohne_o) <+
-0.1151044334e-2*ota_mbsim3v3_pmbtrans20_w*V(f_pmbtrans20_leff_cv)*(V(f_pmbtrans20_vgsteff)-0.5*V(f_pmbtrans20_vdseff_cv)+V(f_pmbtrans20_abulk_cv)*pow(V(f_pmbtrans20_vdseff_cv),2)/V(f_pmbtrans20_faktor_t1))-0.1151044334e-2*ota_mbsim3v3_pmbtrans20_w*V(f_pmbtrans20_leff_cv)*(1.0-1.0*V(f_pmbtrans20_abulk_cv))*(0.5*V(f_pmbtrans20_vdseff_cv)-1.0*V(f_pmbtrans20_abulk_cv)*pow(V(f_pmbtrans20_vdseff_cv),2)/V(f_pmbtrans20_faktor_t1))   ;
 V(f_pmbtrans20_g_qg) <+
0.2302088667e-2*ota_mbsim3v3_pmbtrans20_w*V(f_pmbtrans20_leff_cv)*(V(f_pmbtrans20_vgsteff)-0.5*V(f_pmbtrans20_vdseff_cv)+V(f_pmbtrans20_abulk_cv)*pow(V(f_pmbtrans20_vdseff_cv),2)/V(f_pmbtrans20_faktor_t1))+V(f_pmbtrans20_qac0)+V(f_pmbtrans20_qsub0)   ;
 V(f_pmbtrans20_qg) <+
V(f_pmbtrans20_g_qg)+V(f_pmbtrans20_qoverlap_s)+V(f_pmbtrans20_qoverlap_d)   ;
 V(f_pmbtrans20_g_qb) <+
0.2302088667e-2*ota_mbsim3v3_pmbtrans20_w*V(f_pmbtrans20_leff_cv)*(1.0-1.0*V(f_pmbtrans20_abulk_cv))*(0.5*V(f_pmbtrans20_vdseff_cv)-1.0*V(f_pmbtrans20_abulk_cv)*pow(V(f_pmbtrans20_vdseff_cv),2)/V(f_pmbtrans20_faktor_t1))-1.0*V(f_pmbtrans20_qac0)-1.0*V(f_pmbtrans20_qsub0)   ;
 V(f_pmbtrans20_qb) <+
V(f_pmbtrans20_g_qb)   ;
 V(f_pmbtrans20_g_qd) <+
-1.0*V(f_pmbtrans20_g_qg)-1.0*V(f_pmbtrans20_qs_ohne_o)-1.0*V(f_pmbtrans20_g_qb)   ;
 V(f_pmbtrans20_qd) <+
(1.0-1.0*V(f_pmbtrans20_dir))*(V(f_pmbtrans20_g_qd)-1.0*V(f_pmbtrans20_qoverlap_d))+V(f_pmbtrans20_dir)*(V(f_pmbtrans20_qs_ohne_o)-1.0*V(f_pmbtrans20_qoverlap_d))   ;
 V(f_pmbtrans20_qs) <+
(1.0-1.0*V(f_pmbtrans20_dir))*(V(f_pmbtrans20_qs_ohne_o)-1.0*V(f_pmbtrans20_qoverlap_s))+V(f_pmbtrans20_dir)*(V(f_pmbtrans20_g_qd)-1.0*V(f_pmbtrans20_qoverlap_s))   ;

 // --- Ende der expliziten Gleichungen ---

 // --- Begin der impliziten Gleichungen ---

 // Vars ohne:
  I(u_int1) <+
-1.0*V(f_pmtrans1_ids)+0.300e-11*V(u_int1)-0.100e-11*V(vdd)-1.0*ddt(_a24*V(f_pmtrans1_qd))-1.0*ddt(_a24*V(f_pmtrans1_qg))-1.0*ddt(_a48*V(f_pmtrans2_qg))+1.0*V(f_nmtrans1_ids)-0.100e-11*V(gnd)-1.0*ddt(-1.0*_a72*V(f_nmtrans1_qd))-1.0*V(f_pmbtrans9_ids)-0.100e-11*V(pbias)-1.0*ddt(_a144*V(f_pmbtrans9_qd))   ;

 // Subs-Diff Gleichungen:

 // Stromgleichungen:
  I(p_in) <+ -1.0 * (
  (   ddt(_a144*V(f_pmbtrans9_qg))   ) ) ;
  I(n_in) <+ -1.0 * (
  (   ddt(_a168*V(f_pmbtrans20_qg))   ) ) ;
  I(out1) <+ -1.0 * (
  (   V(f_pmtrans2_ids)-0.30e-11*V(out1)+0.10e-11*V(vdd)+ddt(_a48*V(f_pmtrans2_qd))-1.0*V(f_nmtrans2_ids)+0.10e-11*V(gnd)+ddt(-1.0*_a96*V(f_nmtrans2_qd))+V(f_pmbtrans20_ids)+0.10e-11*V(pbias)+ddt(_a168*V(f_pmbtrans20_qd))   ) ) ;
  I(pbias) <+ -1.0 * (
  (   -1.0*V(f_pmbtrans9_ids)+0.10e-11*V(u_int1)-0.20e-11*V(pbias)+ddt(_a144*V(f_pmbtrans9_qs))-1.0*V(f_pmbtrans20_ids)+0.10e-11*V(out1)+ddt(_a168*V(f_pmbtrans20_qs))   ) ) ;
  I(nbias) <+ -1.0 * (
  (   ddt(-1.0*_a72*V(f_nmtrans1_qg))+ddt(-1.0*_a96*V(f_nmtrans2_qg))-1.0*V(f_nmtrans3_ids)-0.10e-11*V(nbias)+0.10e-11*V(gnd)+ddt(-1.0*_a120*V(f_nmtrans3_qd))+ddt(-1.0*_a120*V(f_nmtrans3_qg))   ) ) ;
  I(vdd) <+ -1.0 * (
  (   ddt(_a24*V(f_pmtrans1_qb))-1.0*V(f_pmtrans1_ids)+0.10e-11*V(u_int1)-0.20e-11*V(vdd)+ddt(_a24*V(f_pmtrans1_qs))+ddt(_a48*V(f_pmtrans2_qb))-1.0*V(f_pmtrans2_ids)+0.10e-11*V(out1)+ddt(_a48*V(f_pmtrans2_qs))+ddt(_a144*V(f_pmbtrans9_qb))+ddt(_a168*V(f_pmbtrans20_qb))   ) ) ;
  I(gnd) <+ -1.0 * (
  (   ddt(-1.0*_a72*V(f_nmtrans1_qb))+V(f_nmtrans1_ids)+0.10e-11*V(u_int1)-0.30e-11*V(gnd)+ddt(-1.0*_a72*V(f_nmtrans1_qs))+ddt(-1.0*_a96*V(f_nmtrans2_qb))+V(f_nmtrans2_ids)+0.10e-11*V(out1)+ddt(-1.0*_a96*V(f_nmtrans2_qs))+ddt(-1.0*_a120*V(f_nmtrans3_qb))+V(f_nmtrans3_ids)+0.10e-11*V(nbias)+ddt(-1.0*_a120*V(f_nmtrans3_qs))   ) ) ;

  end
endmodule
